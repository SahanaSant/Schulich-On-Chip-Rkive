* NGSPICE file created from udma_uart_top.ext - technology: gf180mcuD

* Black-box entry subcircuit for gf180mcu_fd_sc_mcu7t5v0__dffrnq_1 abstract view
.subckt gf180mcu_fd_sc_mcu7t5v0__dffrnq_1 D RN CLK Q VDD VNW VPW VSS
.ends

* Black-box entry subcircuit for gf180mcu_fd_sc_mcu7t5v0__fillcap_32 abstract view
.subckt gf180mcu_fd_sc_mcu7t5v0__fillcap_32 VDD VNW VPW VSS
.ends

* Black-box entry subcircuit for gf180mcu_fd_sc_mcu7t5v0__fillcap_4 abstract view
.subckt gf180mcu_fd_sc_mcu7t5v0__fillcap_4 VDD VNW VPW VSS
.ends

* Black-box entry subcircuit for gf180mcu_fd_sc_mcu7t5v0__fillcap_16 abstract view
.subckt gf180mcu_fd_sc_mcu7t5v0__fillcap_16 VDD VNW VPW VSS
.ends

* Black-box entry subcircuit for gf180mcu_fd_sc_mcu7t5v0__fillcap_8 abstract view
.subckt gf180mcu_fd_sc_mcu7t5v0__fillcap_8 VDD VNW VPW VSS
.ends

* Black-box entry subcircuit for gf180mcu_fd_sc_mcu7t5v0__filltie abstract view
.subckt gf180mcu_fd_sc_mcu7t5v0__filltie VDD VSS
.ends

* Black-box entry subcircuit for gf180mcu_fd_sc_mcu7t5v0__nor4_1 abstract view
.subckt gf180mcu_fd_sc_mcu7t5v0__nor4_1 A1 A2 A3 A4 ZN VDD VNW VPW VSS
.ends

* Black-box entry subcircuit for gf180mcu_fd_sc_mcu7t5v0__fill_1 abstract view
.subckt gf180mcu_fd_sc_mcu7t5v0__fill_1 VDD VNW VPW VSS
.ends

* Black-box entry subcircuit for gf180mcu_fd_sc_mcu7t5v0__fill_2 abstract view
.subckt gf180mcu_fd_sc_mcu7t5v0__fill_2 VDD VNW VPW VSS
.ends

* Black-box entry subcircuit for gf180mcu_fd_sc_mcu7t5v0__nand4_1 abstract view
.subckt gf180mcu_fd_sc_mcu7t5v0__nand4_1 A1 A2 A3 A4 ZN VDD VNW VPW VSS
.ends

* Black-box entry subcircuit for gf180mcu_fd_sc_mcu7t5v0__clkbuf_2 abstract view
.subckt gf180mcu_fd_sc_mcu7t5v0__clkbuf_2 I Z VDD VNW VPW VSS
.ends

* Black-box entry subcircuit for gf180mcu_fd_sc_mcu7t5v0__mux2_2 abstract view
.subckt gf180mcu_fd_sc_mcu7t5v0__mux2_2 I0 I1 S Z VDD VNW VPW VSS
.ends

* Black-box entry subcircuit for gf180mcu_fd_sc_mcu7t5v0__and3_1 abstract view
.subckt gf180mcu_fd_sc_mcu7t5v0__and3_1 A1 A2 A3 Z VDD VNW VPW VSS
.ends

* Black-box entry subcircuit for gf180mcu_fd_sc_mcu7t5v0__clkinv_1 abstract view
.subckt gf180mcu_fd_sc_mcu7t5v0__clkinv_1 I ZN VDD VNW VPW VSS
.ends

* Black-box entry subcircuit for gf180mcu_fd_sc_mcu7t5v0__nor3_1 abstract view
.subckt gf180mcu_fd_sc_mcu7t5v0__nor3_1 A1 A2 A3 ZN VDD VNW VPW VSS
.ends

* Black-box entry subcircuit for gf180mcu_fd_sc_mcu7t5v0__nand2_1 abstract view
.subckt gf180mcu_fd_sc_mcu7t5v0__nand2_1 A1 A2 ZN VDD VNW VPW VSS
.ends

* Black-box entry subcircuit for gf180mcu_fd_sc_mcu7t5v0__and4_1 abstract view
.subckt gf180mcu_fd_sc_mcu7t5v0__and4_1 A1 A2 A3 A4 Z VDD VNW VPW VSS
.ends

* Black-box entry subcircuit for gf180mcu_fd_sc_mcu7t5v0__and2_1 abstract view
.subckt gf180mcu_fd_sc_mcu7t5v0__and2_1 A1 A2 Z VDD VNW VPW VSS
.ends

* Black-box entry subcircuit for gf180mcu_fd_sc_mcu7t5v0__buf_1 abstract view
.subckt gf180mcu_fd_sc_mcu7t5v0__buf_1 I Z VDD VNW VPW VSS
.ends

* Black-box entry subcircuit for gf180mcu_fd_sc_mcu7t5v0__fillcap_64 abstract view
.subckt gf180mcu_fd_sc_mcu7t5v0__fillcap_64 VDD VNW VPW VSS
.ends

* Black-box entry subcircuit for gf180mcu_fd_sc_mcu7t5v0__clkbuf_3 abstract view
.subckt gf180mcu_fd_sc_mcu7t5v0__clkbuf_3 I Z VDD VNW VPW VSS
.ends

* Black-box entry subcircuit for gf180mcu_fd_sc_mcu7t5v0__mux4_1 abstract view
.subckt gf180mcu_fd_sc_mcu7t5v0__mux4_1 I0 I1 I2 I3 S0 S1 Z VDD VNW VPW VSS
.ends

* Black-box entry subcircuit for gf180mcu_fd_sc_mcu7t5v0__oai32_1 abstract view
.subckt gf180mcu_fd_sc_mcu7t5v0__oai32_1 A1 A2 A3 B1 B2 ZN VDD VNW VPW VSS
.ends

* Black-box entry subcircuit for gf180mcu_fd_sc_mcu7t5v0__or2_1 abstract view
.subckt gf180mcu_fd_sc_mcu7t5v0__or2_1 A1 A2 Z VDD VNW VPW VSS
.ends

* Black-box entry subcircuit for gf180mcu_fd_sc_mcu7t5v0__xor2_1 abstract view
.subckt gf180mcu_fd_sc_mcu7t5v0__xor2_1 A1 A2 Z VDD VNW VPW VSS
.ends

* Black-box entry subcircuit for gf180mcu_fd_sc_mcu7t5v0__oai211_1 abstract view
.subckt gf180mcu_fd_sc_mcu7t5v0__oai211_1 A1 A2 B C ZN VDD VNW VPW VSS
.ends

* Black-box entry subcircuit for gf180mcu_fd_sc_mcu7t5v0__dlyb_1 abstract view
.subckt gf180mcu_fd_sc_mcu7t5v0__dlyb_1 I Z VDD VNW VPW VSS
.ends

* Black-box entry subcircuit for gf180mcu_fd_sc_mcu7t5v0__aoi22_1 abstract view
.subckt gf180mcu_fd_sc_mcu7t5v0__aoi22_1 A1 A2 B1 B2 ZN VDD VNW VPW VSS
.ends

* Black-box entry subcircuit for gf180mcu_fd_sc_mcu7t5v0__dlyc_1 abstract view
.subckt gf180mcu_fd_sc_mcu7t5v0__dlyc_1 I Z VDD VNW VPW VSS
.ends

* Black-box entry subcircuit for gf180mcu_fd_sc_mcu7t5v0__clkbuf_1 abstract view
.subckt gf180mcu_fd_sc_mcu7t5v0__clkbuf_1 I Z VDD VNW VPW VSS
.ends

* Black-box entry subcircuit for gf180mcu_fd_sc_mcu7t5v0__nor2_1 abstract view
.subckt gf180mcu_fd_sc_mcu7t5v0__nor2_1 A1 A2 ZN VDD VNW VPW VSS
.ends

* Black-box entry subcircuit for gf180mcu_fd_sc_mcu7t5v0__tiel abstract view
.subckt gf180mcu_fd_sc_mcu7t5v0__tiel ZN VDD VNW VPW VSS
.ends

* Black-box entry subcircuit for gf180mcu_fd_sc_mcu7t5v0__aoi21_1 abstract view
.subckt gf180mcu_fd_sc_mcu7t5v0__aoi21_1 A1 A2 B ZN VDD VNW VPW VSS
.ends

* Black-box entry subcircuit for gf180mcu_fd_sc_mcu7t5v0__nand3_1 abstract view
.subckt gf180mcu_fd_sc_mcu7t5v0__nand3_1 A1 A2 A3 ZN VDD VNW VPW VSS
.ends

* Black-box entry subcircuit for gf180mcu_fd_sc_mcu7t5v0__endcap abstract view
.subckt gf180mcu_fd_sc_mcu7t5v0__endcap VDD VSS
.ends

* Black-box entry subcircuit for gf180mcu_fd_sc_mcu7t5v0__oai21_1 abstract view
.subckt gf180mcu_fd_sc_mcu7t5v0__oai21_1 A1 A2 B ZN VDD VNW VPW VSS
.ends

* Black-box entry subcircuit for gf180mcu_fd_sc_mcu7t5v0__clkbuf_16 abstract view
.subckt gf180mcu_fd_sc_mcu7t5v0__clkbuf_16 I Z VDD VNW VPW VSS
.ends

* Black-box entry subcircuit for gf180mcu_fd_sc_mcu7t5v0__dffsnq_1 abstract view
.subckt gf180mcu_fd_sc_mcu7t5v0__dffsnq_1 D SETN CLK Q VDD VNW VPW VSS
.ends

* Black-box entry subcircuit for gf180mcu_fd_sc_mcu7t5v0__aoi221_1 abstract view
.subckt gf180mcu_fd_sc_mcu7t5v0__aoi221_1 A1 A2 B1 B2 C ZN VDD VNW VPW VSS
.ends

* Black-box entry subcircuit for gf180mcu_fd_sc_mcu7t5v0__buf_2 abstract view
.subckt gf180mcu_fd_sc_mcu7t5v0__buf_2 I Z VDD VNW VPW VSS
.ends

* Black-box entry subcircuit for gf180mcu_fd_sc_mcu7t5v0__oai221_1 abstract view
.subckt gf180mcu_fd_sc_mcu7t5v0__oai221_1 A1 A2 B1 B2 C ZN VDD VNW VPW VSS
.ends

* Black-box entry subcircuit for gf180mcu_fd_sc_mcu7t5v0__or3_1 abstract view
.subckt gf180mcu_fd_sc_mcu7t5v0__or3_1 A1 A2 A3 Z VDD VNW VPW VSS
.ends

* Black-box entry subcircuit for gf180mcu_fd_sc_mcu7t5v0__aoi211_1 abstract view
.subckt gf180mcu_fd_sc_mcu7t5v0__aoi211_1 A1 A2 B C ZN VDD VNW VPW VSS
.ends

* Black-box entry subcircuit for gf180mcu_fd_sc_mcu7t5v0__xor3_1 abstract view
.subckt gf180mcu_fd_sc_mcu7t5v0__xor3_1 A1 A2 A3 Z VDD VNW VPW VSS
.ends

* Black-box entry subcircuit for gf180mcu_fd_sc_mcu7t5v0__aoi222_1 abstract view
.subckt gf180mcu_fd_sc_mcu7t5v0__aoi222_1 A1 A2 B1 B2 C1 C2 ZN VDD VNW VPW VSS
.ends

* Black-box entry subcircuit for gf180mcu_fd_sc_mcu7t5v0__oai22_1 abstract view
.subckt gf180mcu_fd_sc_mcu7t5v0__oai22_1 A1 A2 B1 B2 ZN VDD VNW VPW VSS
.ends

* Black-box entry subcircuit for gf180mcu_fd_sc_mcu7t5v0__buf_4 abstract view
.subckt gf180mcu_fd_sc_mcu7t5v0__buf_4 I Z VDD VNW VPW VSS
.ends

* Black-box entry subcircuit for gf180mcu_fd_sc_mcu7t5v0__dlya_1 abstract view
.subckt gf180mcu_fd_sc_mcu7t5v0__dlya_1 I Z VDD VNW VPW VSS
.ends

* Black-box entry subcircuit for gf180mcu_fd_sc_mcu7t5v0__oai222_1 abstract view
.subckt gf180mcu_fd_sc_mcu7t5v0__oai222_1 A1 A2 B1 B2 C1 C2 ZN VDD VNW VPW VSS
.ends

* Black-box entry subcircuit for gf180mcu_fd_sc_mcu7t5v0__nor4_2 abstract view
.subckt gf180mcu_fd_sc_mcu7t5v0__nor4_2 A1 A2 A3 A4 ZN VDD VNW VPW VSS
.ends

* Black-box entry subcircuit for gf180mcu_fd_sc_mcu7t5v0__oai31_1 abstract view
.subckt gf180mcu_fd_sc_mcu7t5v0__oai31_1 A1 A2 A3 B ZN VDD VNW VPW VSS
.ends

* Black-box entry subcircuit for gf180mcu_fd_sc_mcu7t5v0__xnor2_1 abstract view
.subckt gf180mcu_fd_sc_mcu7t5v0__xnor2_1 A1 A2 ZN VDD VNW VPW VSS
.ends

* Black-box entry subcircuit for gf180mcu_fd_sc_mcu7t5v0__aoi22_2 abstract view
.subckt gf180mcu_fd_sc_mcu7t5v0__aoi22_2 A1 A2 B1 B2 ZN VDD VNW VPW VSS
.ends

* Black-box entry subcircuit for gf180mcu_fd_sc_mcu7t5v0__buf_3 abstract view
.subckt gf180mcu_fd_sc_mcu7t5v0__buf_3 I Z VDD VNW VPW VSS
.ends

* Black-box entry subcircuit for gf180mcu_fd_sc_mcu7t5v0__nand4_2 abstract view
.subckt gf180mcu_fd_sc_mcu7t5v0__nand4_2 A1 A2 A3 A4 ZN VDD VNW VPW VSS
.ends

* Black-box entry subcircuit for gf180mcu_fd_sc_mcu7t5v0__nand3_4 abstract view
.subckt gf180mcu_fd_sc_mcu7t5v0__nand3_4 A1 A2 A3 ZN VDD VNW VPW VSS
.ends

* Black-box entry subcircuit for gf180mcu_fd_sc_mcu7t5v0__tieh abstract view
.subckt gf180mcu_fd_sc_mcu7t5v0__tieh Z VDD VNW VPW VSS
.ends

* Black-box entry subcircuit for gf180mcu_fd_sc_mcu7t5v0__antenna abstract view
.subckt gf180mcu_fd_sc_mcu7t5v0__antenna I VDD VNW VPW VSS
.ends

.subckt udma_uart_top VDD VSS cfg_addr_i[0] cfg_addr_i[1] cfg_addr_i[2] cfg_addr_i[3]
+ cfg_addr_i[4] cfg_data_i[0] cfg_data_i[10] cfg_data_i[11] cfg_data_i[12] cfg_data_i[13]
+ cfg_data_i[14] cfg_data_i[15] cfg_data_i[16] cfg_data_i[17] cfg_data_i[18] cfg_data_i[19]
+ cfg_data_i[1] cfg_data_i[20] cfg_data_i[21] cfg_data_i[22] cfg_data_i[23] cfg_data_i[24]
+ cfg_data_i[25] cfg_data_i[26] cfg_data_i[27] cfg_data_i[28] cfg_data_i[29] cfg_data_i[2]
+ cfg_data_i[30] cfg_data_i[31] cfg_data_i[3] cfg_data_i[4] cfg_data_i[5] cfg_data_i[6]
+ cfg_data_i[7] cfg_data_i[8] cfg_data_i[9] cfg_data_o[0] cfg_data_o[10] cfg_data_o[11]
+ cfg_data_o[12] cfg_data_o[13] cfg_data_o[14] cfg_data_o[15] cfg_data_o[16] cfg_data_o[17]
+ cfg_data_o[18] cfg_data_o[19] cfg_data_o[1] cfg_data_o[20] cfg_data_o[21] cfg_data_o[22]
+ cfg_data_o[23] cfg_data_o[24] cfg_data_o[25] cfg_data_o[26] cfg_data_o[27] cfg_data_o[28]
+ cfg_data_o[29] cfg_data_o[2] cfg_data_o[30] cfg_data_o[31] cfg_data_o[3] cfg_data_o[4]
+ cfg_data_o[5] cfg_data_o[6] cfg_data_o[7] cfg_data_o[8] cfg_data_o[9] cfg_ready_o
+ cfg_rwn_i cfg_rx_bytes_left_i[0] cfg_rx_bytes_left_i[10] cfg_rx_bytes_left_i[11]
+ cfg_rx_bytes_left_i[12] cfg_rx_bytes_left_i[13] cfg_rx_bytes_left_i[14] cfg_rx_bytes_left_i[15]
+ cfg_rx_bytes_left_i[1] cfg_rx_bytes_left_i[2] cfg_rx_bytes_left_i[3] cfg_rx_bytes_left_i[4]
+ cfg_rx_bytes_left_i[5] cfg_rx_bytes_left_i[6] cfg_rx_bytes_left_i[7] cfg_rx_bytes_left_i[8]
+ cfg_rx_bytes_left_i[9] cfg_rx_clr_o cfg_rx_continuous_o cfg_rx_curr_addr_i[0] cfg_rx_curr_addr_i[10]
+ cfg_rx_curr_addr_i[11] cfg_rx_curr_addr_i[1] cfg_rx_curr_addr_i[2] cfg_rx_curr_addr_i[3]
+ cfg_rx_curr_addr_i[4] cfg_rx_curr_addr_i[5] cfg_rx_curr_addr_i[6] cfg_rx_curr_addr_i[7]
+ cfg_rx_curr_addr_i[8] cfg_rx_curr_addr_i[9] cfg_rx_datasize_o[0] cfg_rx_datasize_o[1]
+ cfg_rx_en_i cfg_rx_en_o cfg_rx_pending_i cfg_rx_size_o[0] cfg_rx_size_o[10] cfg_rx_size_o[11]
+ cfg_rx_size_o[12] cfg_rx_size_o[13] cfg_rx_size_o[14] cfg_rx_size_o[15] cfg_rx_size_o[1]
+ cfg_rx_size_o[2] cfg_rx_size_o[3] cfg_rx_size_o[4] cfg_rx_size_o[5] cfg_rx_size_o[6]
+ cfg_rx_size_o[7] cfg_rx_size_o[8] cfg_rx_size_o[9] cfg_rx_startaddr_o[0] cfg_rx_startaddr_o[10]
+ cfg_rx_startaddr_o[11] cfg_rx_startaddr_o[1] cfg_rx_startaddr_o[2] cfg_rx_startaddr_o[3]
+ cfg_rx_startaddr_o[4] cfg_rx_startaddr_o[5] cfg_rx_startaddr_o[6] cfg_rx_startaddr_o[7]
+ cfg_rx_startaddr_o[8] cfg_rx_startaddr_o[9] cfg_tx_bytes_left_i[0] cfg_tx_bytes_left_i[10]
+ cfg_tx_bytes_left_i[11] cfg_tx_bytes_left_i[12] cfg_tx_bytes_left_i[13] cfg_tx_bytes_left_i[14]
+ cfg_tx_bytes_left_i[15] cfg_tx_bytes_left_i[1] cfg_tx_bytes_left_i[2] cfg_tx_bytes_left_i[3]
+ cfg_tx_bytes_left_i[4] cfg_tx_bytes_left_i[5] cfg_tx_bytes_left_i[6] cfg_tx_bytes_left_i[7]
+ cfg_tx_bytes_left_i[8] cfg_tx_bytes_left_i[9] cfg_tx_clr_o cfg_tx_continuous_o cfg_tx_curr_addr_i[0]
+ cfg_tx_curr_addr_i[10] cfg_tx_curr_addr_i[11] cfg_tx_curr_addr_i[1] cfg_tx_curr_addr_i[2]
+ cfg_tx_curr_addr_i[3] cfg_tx_curr_addr_i[4] cfg_tx_curr_addr_i[5] cfg_tx_curr_addr_i[6]
+ cfg_tx_curr_addr_i[7] cfg_tx_curr_addr_i[8] cfg_tx_curr_addr_i[9] cfg_tx_datasize_o[0]
+ cfg_tx_datasize_o[1] cfg_tx_en_i cfg_tx_en_o cfg_tx_pending_i cfg_tx_size_o[0] cfg_tx_size_o[10]
+ cfg_tx_size_o[11] cfg_tx_size_o[12] cfg_tx_size_o[13] cfg_tx_size_o[14] cfg_tx_size_o[15]
+ cfg_tx_size_o[1] cfg_tx_size_o[2] cfg_tx_size_o[3] cfg_tx_size_o[4] cfg_tx_size_o[5]
+ cfg_tx_size_o[6] cfg_tx_size_o[7] cfg_tx_size_o[8] cfg_tx_size_o[9] cfg_tx_startaddr_o[0]
+ cfg_tx_startaddr_o[10] cfg_tx_startaddr_o[11] cfg_tx_startaddr_o[1] cfg_tx_startaddr_o[2]
+ cfg_tx_startaddr_o[3] cfg_tx_startaddr_o[4] cfg_tx_startaddr_o[5] cfg_tx_startaddr_o[6]
+ cfg_tx_startaddr_o[7] cfg_tx_startaddr_o[8] cfg_tx_startaddr_o[9] cfg_valid_i data_rx_datasize_o[0]
+ data_rx_datasize_o[1] data_rx_o[0] data_rx_o[10] data_rx_o[11] data_rx_o[12] data_rx_o[13]
+ data_rx_o[14] data_rx_o[15] data_rx_o[16] data_rx_o[17] data_rx_o[18] data_rx_o[19]
+ data_rx_o[1] data_rx_o[20] data_rx_o[21] data_rx_o[22] data_rx_o[23] data_rx_o[24]
+ data_rx_o[25] data_rx_o[26] data_rx_o[27] data_rx_o[28] data_rx_o[29] data_rx_o[2]
+ data_rx_o[30] data_rx_o[31] data_rx_o[3] data_rx_o[4] data_rx_o[5] data_rx_o[6]
+ data_rx_o[7] data_rx_o[8] data_rx_o[9] data_rx_ready_i data_rx_valid_o data_tx_datasize_o[0]
+ data_tx_datasize_o[1] data_tx_gnt_i data_tx_i[0] data_tx_i[10] data_tx_i[11] data_tx_i[12]
+ data_tx_i[13] data_tx_i[14] data_tx_i[15] data_tx_i[16] data_tx_i[17] data_tx_i[18]
+ data_tx_i[19] data_tx_i[1] data_tx_i[20] data_tx_i[21] data_tx_i[22] data_tx_i[23]
+ data_tx_i[24] data_tx_i[25] data_tx_i[26] data_tx_i[27] data_tx_i[28] data_tx_i[29]
+ data_tx_i[2] data_tx_i[30] data_tx_i[31] data_tx_i[3] data_tx_i[4] data_tx_i[5]
+ data_tx_i[6] data_tx_i[7] data_tx_i[8] data_tx_i[9] data_tx_ready_o data_tx_req_o
+ data_tx_valid_i err_event_o periph_clk_i rstn_i rx_char_event_o sys_clk_i uart_rx_i
+ uart_tx_o
X_2106_ _2106_/D _2108_/RN clkload8/I _2106_/Q VDD VDD VSS VSS gf180mcu_fd_sc_mcu7t5v0__dffrnq_1
XFILLER_82_545 VDD VDD VSS VSS gf180mcu_fd_sc_mcu7t5v0__fillcap_32
X_2037_ _2037_/D _2127_/RN _2037_/CLK _2103_/D VDD VDD VSS VSS gf180mcu_fd_sc_mcu7t5v0__dffrnq_1
XFILLER_54_247 VDD VDD VSS VSS gf180mcu_fd_sc_mcu7t5v0__fillcap_32
XFILLER_82_589 VDD VDD VSS VSS gf180mcu_fd_sc_mcu7t5v0__fillcap_4
XFILLER_22_177 VDD VDD VSS VSS gf180mcu_fd_sc_mcu7t5v0__fillcap_16
XFILLER_50_486 VDD VDD VSS VSS gf180mcu_fd_sc_mcu7t5v0__fillcap_8
XFILLER_77_328 VDD VDD VSS VSS gf180mcu_fd_sc_mcu7t5v0__fillcap_4
XFILLER_85_383 VDD VDD VSS VSS gf180mcu_fd_sc_mcu7t5v0__fillcap_32
XFILLER_73_534 VDD VDD VSS VSS gf180mcu_fd_sc_mcu7t5v0__fillcap_16
XTAP_TAPCELL_ROW_56_743 VDD VSS gf180mcu_fd_sc_mcu7t5v0__filltie
XTAP_TAPCELL_ROW_28_478 VDD VSS gf180mcu_fd_sc_mcu7t5v0__filltie
XFILLER_26_96 VDD VDD VSS VSS gf180mcu_fd_sc_mcu7t5v0__fillcap_8
XFILLER_60_239 VDD VDD VSS VSS gf180mcu_fd_sc_mcu7t5v0__fillcap_4
XFILLER_14_667 VDD VDD VSS VSS gf180mcu_fd_sc_mcu7t5v0__fillcap_16
XFILLER_68_317 VDD VDD VSS VSS gf180mcu_fd_sc_mcu7t5v0__fillcap_32
XFILLER_3_34 VDD VDD VSS VSS gf180mcu_fd_sc_mcu7t5v0__fillcap_16
X_1270_ _1270_/A1 _1270_/A2 _1274_/A1 _1270_/A4 _1289_/A2 VDD VDD VSS VSS gf180mcu_fd_sc_mcu7t5v0__nor4_1
XFILLER_95_136 VDD VDD VSS VSS gf180mcu_fd_sc_mcu7t5v0__fillcap_4
XFILLER_64_512 VDD VDD VSS VSS gf180mcu_fd_sc_mcu7t5v0__fill_1
XFILLER_17_450 VDD VDD VSS VSS gf180mcu_fd_sc_mcu7t5v0__fill_1
XFILLER_17_483 VDD VDD VSS VSS gf180mcu_fd_sc_mcu7t5v0__fillcap_4
XFILLER_91_364 VDD VDD VSS VSS gf180mcu_fd_sc_mcu7t5v0__fill_1
XFILLER_32_453 VDD VDD VSS VSS gf180mcu_fd_sc_mcu7t5v0__fill_2
XFILLER_80_2 VDD VDD VSS VSS gf180mcu_fd_sc_mcu7t5v0__fillcap_32
X_0985_ _0986_/A1 _1893_/Q _2149_/Q _1894_/Q _0991_/A1 VDD VDD VSS VSS gf180mcu_fd_sc_mcu7t5v0__nand4_1
Xclkbuf_4_1_0_periph_clk_i clkbuf_0_periph_clk_i/Z clkbuf_4_1_0_periph_clk_i/Z VDD
+ VDD VSS VSS gf180mcu_fd_sc_mcu7t5v0__clkbuf_2
X_1606_ input17/Z _1979_/Q _1611_/S _1979_/D VDD VDD VSS VSS gf180mcu_fd_sc_mcu7t5v0__mux2_2
X_1537_ _1538_/A2 _1538_/A3 _1045_/C _1537_/Z VDD VDD VSS VSS gf180mcu_fd_sc_mcu7t5v0__and3_1
X_1468_ _1945_/Q _1953_/Q _1472_/S _1468_/Z VDD VDD VSS VSS gf180mcu_fd_sc_mcu7t5v0__mux2_2
X_1399_ _1399_/I _1399_/ZN VDD VDD VSS VSS gf180mcu_fd_sc_mcu7t5v0__clkinv_1
XFILLER_95_692 VDD VDD VSS VSS gf180mcu_fd_sc_mcu7t5v0__fill_2
XTAP_TAPCELL_ROW_53_713 VDD VSS gf180mcu_fd_sc_mcu7t5v0__filltie
XFILLER_55_578 VDD VDD VSS VSS gf180mcu_fd_sc_mcu7t5v0__fill_2
XTAP_TAPCELL_ROW_25_448 VDD VSS gf180mcu_fd_sc_mcu7t5v0__filltie
XFILLER_23_497 VDD VDD VSS VSS gf180mcu_fd_sc_mcu7t5v0__fillcap_16
XTAP_TAPCELL_ROW_61_790 VDD VSS gf180mcu_fd_sc_mcu7t5v0__filltie
XFILLER_6_107 VDD VDD VSS VSS gf180mcu_fd_sc_mcu7t5v0__fillcap_4
XFILLER_77_169 VDD VDD VSS VSS gf180mcu_fd_sc_mcu7t5v0__fillcap_4
XFILLER_37_51 VDD VDD VSS VSS gf180mcu_fd_sc_mcu7t5v0__fillcap_16
XFILLER_18_247 VDD VDD VSS VSS gf180mcu_fd_sc_mcu7t5v0__fillcap_32
XFILLER_61_526 VDD VDD VSS VSS gf180mcu_fd_sc_mcu7t5v0__fillcap_32
XFILLER_53_72 VDD VDD VSS VSS gf180mcu_fd_sc_mcu7t5v0__fillcap_32
XFILLER_68_103 VDD VDD VSS VSS gf180mcu_fd_sc_mcu7t5v0__fill_2
X_1322_ _1604_/A3 _1338_/A2 _0907_/I _1373_/A3 VDD VDD VSS VSS gf180mcu_fd_sc_mcu7t5v0__nor3_1
X_1253_ _1253_/A1 _1253_/A2 _1255_/A2 VDD VDD VSS VSS gf180mcu_fd_sc_mcu7t5v0__nand2_1
XFILLER_56_309 VDD VDD VSS VSS gf180mcu_fd_sc_mcu7t5v0__fillcap_4
XTAP_TAPCELL_ROW_67_849 VDD VSS gf180mcu_fd_sc_mcu7t5v0__filltie
X_1184_ _1191_/A1 _1964_/Q _1191_/A3 _1191_/A4 _1184_/Z VDD VDD VSS VSS gf180mcu_fd_sc_mcu7t5v0__and4_1
XFILLER_52_504 VDD VDD VSS VSS gf180mcu_fd_sc_mcu7t5v0__fillcap_16
XTAP_TAPCELL_ROW_22_418 VDD VSS gf180mcu_fd_sc_mcu7t5v0__filltie
X_0968_ _1332_/A3 _1376_/A2 _0968_/Z VDD VDD VSS VSS gf180mcu_fd_sc_mcu7t5v0__and2_1
XTAP_TAPCELL_ROW_30_495 VDD VSS gf180mcu_fd_sc_mcu7t5v0__filltie
Xoutput220 _1316_/ZN wire236/I VDD VDD VSS VSS gf180mcu_fd_sc_mcu7t5v0__buf_1
XTAP_TAPCELL_ROW_38_573 VDD VSS gf180mcu_fd_sc_mcu7t5v0__filltie
XFILLER_70_301 VDD VDD VSS VSS gf180mcu_fd_sc_mcu7t5v0__fill_2
XFILLER_82_172 VDD VDD VSS VSS gf180mcu_fd_sc_mcu7t5v0__fill_2
XFILLER_43_559 VDD VDD VSS VSS gf180mcu_fd_sc_mcu7t5v0__fill_1
XFILLER_90_37 VDD VDD VSS VSS gf180mcu_fd_sc_mcu7t5v0__fillcap_64
Xwire303 wire303/I cfg_data_o[22] VDD VDD VSS VSS gf180mcu_fd_sc_mcu7t5v0__clkbuf_3
XFILLER_11_489 VDD VDD VSS VSS gf180mcu_fd_sc_mcu7t5v0__fill_1
Xwire358 wire358/I cfg_tx_startaddr_o[5] VDD VDD VSS VSS gf180mcu_fd_sc_mcu7t5v0__clkbuf_3
Xwire369 wire369/I cfg_tx_size_o[6] VDD VDD VSS VSS gf180mcu_fd_sc_mcu7t5v0__clkbuf_3
XFILLER_3_688 VDD VDD VSS VSS gf180mcu_fd_sc_mcu7t5v0__fillcap_4
XFILLER_48_61 VDD VDD VSS VSS gf180mcu_fd_sc_mcu7t5v0__fill_1
XFILLER_59_692 VDD VDD VSS VSS gf180mcu_fd_sc_mcu7t5v0__fill_2
XTAP_TAPCELL_ROW_64_819 VDD VSS gf180mcu_fd_sc_mcu7t5v0__filltie
XFILLER_34_559 VDD VDD VSS VSS gf180mcu_fd_sc_mcu7t5v0__fillcap_16
XFILLER_61_345 VDD VDD VSS VSS gf180mcu_fd_sc_mcu7t5v0__fillcap_4
XFILLER_61_356 VDD VDD VSS VSS gf180mcu_fd_sc_mcu7t5v0__fill_2
XFILLER_14_261 VDD VDD VSS VSS gf180mcu_fd_sc_mcu7t5v0__fillcap_32
X_1940_ _1940_/D _1948_/RN _1949_/CLK _1940_/Q VDD VDD VSS VSS gf180mcu_fd_sc_mcu7t5v0__dffrnq_1
XTAP_TAPCELL_ROW_72_896 VDD VSS gf180mcu_fd_sc_mcu7t5v0__filltie
XFILLER_42_592 VDD VDD VSS VSS gf180mcu_fd_sc_mcu7t5v0__fill_2
X_1871_ _1871_/D _1886_/RN _2061_/CLK _1871_/Q VDD VDD VSS VSS gf180mcu_fd_sc_mcu7t5v0__dffrnq_1
XFILLER_9_66 VDD VDD VSS VSS gf180mcu_fd_sc_mcu7t5v0__fillcap_4
XFILLER_43_2 VDD VDD VSS VSS gf180mcu_fd_sc_mcu7t5v0__fillcap_8
X_1305_ _1880_/Q _1872_/Q _1864_/Q _1856_/Q _1306_/S0 _1306_/S1 _1305_/Z VDD VDD VSS
+ VSS gf180mcu_fd_sc_mcu7t5v0__mux4_1
XFILLER_69_478 VDD VDD VSS VSS gf180mcu_fd_sc_mcu7t5v0__fillcap_4
XFILLER_96_297 VDD VDD VSS VSS gf180mcu_fd_sc_mcu7t5v0__fill_2
XFILLER_69_489 VDD VDD VSS VSS gf180mcu_fd_sc_mcu7t5v0__fill_1
XFILLER_57_629 VDD VDD VSS VSS gf180mcu_fd_sc_mcu7t5v0__fill_1
X_1236_ _2140_/Q _2141_/Q _2142_/Q _1226_/Z _1236_/Z VDD VDD VSS VSS gf180mcu_fd_sc_mcu7t5v0__and4_1
XFILLER_25_504 VDD VDD VSS VSS gf180mcu_fd_sc_mcu7t5v0__fill_2
X_1167_ _1170_/B _1415_/A4 _2052_/Q _1167_/B1 _2180_/Q _2182_/D VDD VDD VSS VSS gf180mcu_fd_sc_mcu7t5v0__oai32_1
X_1098_ _2091_/Q _2167_/Q _1098_/Z VDD VDD VSS VSS gf180mcu_fd_sc_mcu7t5v0__or2_1
XTAP_TAPCELL_ROW_35_543 VDD VSS gf180mcu_fd_sc_mcu7t5v0__filltie
XFILLER_4_419 VDD VDD VSS VSS gf180mcu_fd_sc_mcu7t5v0__fill_2
XFILLER_79_209 VDD VDD VSS VSS gf180mcu_fd_sc_mcu7t5v0__fill_1
XFILLER_0_614 VDD VDD VSS VSS gf180mcu_fd_sc_mcu7t5v0__fill_2
XTAP_TAPCELL_ROW_7_279 VDD VSS gf180mcu_fd_sc_mcu7t5v0__filltie
XFILLER_87_286 VDD VDD VSS VSS gf180mcu_fd_sc_mcu7t5v0__fill_2
XFILLER_28_375 VDD VDD VSS VSS gf180mcu_fd_sc_mcu7t5v0__fillcap_8
XTAP_TAPCELL_ROW_87_1040 VDD VSS gf180mcu_fd_sc_mcu7t5v0__filltie
XFILLER_71_632 VDD VDD VSS VSS gf180mcu_fd_sc_mcu7t5v0__fillcap_32
XFILLER_34_30 VDD VDD VSS VSS gf180mcu_fd_sc_mcu7t5v0__fillcap_4
XFILLER_7_279 VDD VDD VSS VSS gf180mcu_fd_sc_mcu7t5v0__fill_1
XFILLER_3_496 VDD VDD VSS VSS gf180mcu_fd_sc_mcu7t5v0__fill_1
XFILLER_3_474 VDD VDD VSS VSS gf180mcu_fd_sc_mcu7t5v0__fillcap_16
XFILLER_78_242 VDD VDD VSS VSS gf180mcu_fd_sc_mcu7t5v0__fill_2
XFILLER_93_212 VDD VDD VSS VSS gf180mcu_fd_sc_mcu7t5v0__fillcap_64
X_2070_ _2070_/D _2079_/RN _2157_/CLK _2070_/Q VDD VDD VSS VSS gf180mcu_fd_sc_mcu7t5v0__dffrnq_1
XTAP_TAPCELL_ROW_77_944 VDD VSS gf180mcu_fd_sc_mcu7t5v0__filltie
XFILLER_19_342 VDD VDD VSS VSS gf180mcu_fd_sc_mcu7t5v0__fillcap_8
X_1021_ _2085_/Q _2130_/Q _1021_/Z VDD VDD VSS VSS gf180mcu_fd_sc_mcu7t5v0__xor2_1
XTAP_TAPCELL_ROW_49_679 VDD VSS gf180mcu_fd_sc_mcu7t5v0__filltie
XFILLER_81_418 VDD VDD VSS VSS gf180mcu_fd_sc_mcu7t5v0__fill_2
XFILLER_34_367 VDD VDD VSS VSS gf180mcu_fd_sc_mcu7t5v0__fillcap_16
XFILLER_61_142 VDD VDD VSS VSS gf180mcu_fd_sc_mcu7t5v0__fillcap_4
XTAP_TAPCELL_ROW_32_513 VDD VSS gf180mcu_fd_sc_mcu7t5v0__filltie
X_1923_ _1923_/D _1923_/RN _1971_/CLK _1923_/Q VDD VDD VSS VSS gf180mcu_fd_sc_mcu7t5v0__dffrnq_1
X_1854_ _1976_/Q _2101_/Q _1855_/S _2101_/D VDD VDD VSS VSS gf180mcu_fd_sc_mcu7t5v0__mux2_2
X_1785_ _1785_/A1 _1785_/A2 _1785_/B _1785_/C _2073_/D VDD VDD VSS VSS gf180mcu_fd_sc_mcu7t5v0__oai211_1
XTAP_TAPCELL_ROW_40_590 VDD VSS gf180mcu_fd_sc_mcu7t5v0__filltie
Xmax_cap422 _1336_/A2 _1604_/A2 VDD VDD VSS VSS gf180mcu_fd_sc_mcu7t5v0__dlyb_1
XFILLER_97_562 VDD VDD VSS VSS gf180mcu_fd_sc_mcu7t5v0__fillcap_64
XTAP_TAPCELL_ROW_4_249 VDD VSS gf180mcu_fd_sc_mcu7t5v0__filltie
XFILLER_57_459 VDD VDD VSS VSS gf180mcu_fd_sc_mcu7t5v0__fill_2
X_1219_ _2134_/Q _2135_/Q _1205_/Z _1217_/Z _1240_/A1 VDD VDD VSS VSS gf180mcu_fd_sc_mcu7t5v0__nand4_1
XFILLER_65_470 VDD VDD VSS VSS gf180mcu_fd_sc_mcu7t5v0__fillcap_8
XFILLER_13_507 VDD VDD VSS VSS gf180mcu_fd_sc_mcu7t5v0__fillcap_4
XFILLER_80_495 VDD VDD VSS VSS gf180mcu_fd_sc_mcu7t5v0__fillcap_4
XFILLER_80_473 VDD VDD VSS VSS gf180mcu_fd_sc_mcu7t5v0__fill_1
XFILLER_53_687 VDD VDD VSS VSS gf180mcu_fd_sc_mcu7t5v0__fillcap_4
XFILLER_21_562 VDD VDD VSS VSS gf180mcu_fd_sc_mcu7t5v0__fillcap_16
XFILLER_0_433 VDD VDD VSS VSS gf180mcu_fd_sc_mcu7t5v0__fill_2
XFILLER_75_212 VDD VDD VSS VSS gf180mcu_fd_sc_mcu7t5v0__fillcap_16
XFILLER_75_234 VDD VDD VSS VSS gf180mcu_fd_sc_mcu7t5v0__fill_1
XTAP_TAPCELL_ROW_74_914 VDD VSS gf180mcu_fd_sc_mcu7t5v0__filltie
XFILLER_63_418 VDD VDD VSS VSS gf180mcu_fd_sc_mcu7t5v0__fill_2
XTAP_TAPCELL_ROW_46_649 VDD VSS gf180mcu_fd_sc_mcu7t5v0__filltie
XFILLER_71_451 VDD VDD VSS VSS gf180mcu_fd_sc_mcu7t5v0__fillcap_4
XFILLER_43_142 VDD VDD VSS VSS gf180mcu_fd_sc_mcu7t5v0__fillcap_16
XTAP_TAPCELL_ROW_82_991 VDD VSS gf180mcu_fd_sc_mcu7t5v0__filltie
XTAP_TAPCELL_ROW_96_1128 VDD VSS gf180mcu_fd_sc_mcu7t5v0__filltie
XFILLER_8_577 VDD VDD VSS VSS gf180mcu_fd_sc_mcu7t5v0__fillcap_16
XFILLER_6_34 VDD VDD VSS VSS gf180mcu_fd_sc_mcu7t5v0__fill_1
X_1570_ _1570_/I0 _1949_/Q _1571_/S _1949_/D VDD VDD VSS VSS gf180mcu_fd_sc_mcu7t5v0__mux2_2
XFILLER_79_562 VDD VDD VSS VSS gf180mcu_fd_sc_mcu7t5v0__fillcap_4
X_2122_ _2122_/D _2123_/RN clkload8/I _2122_/Q VDD VDD VSS VSS gf180mcu_fd_sc_mcu7t5v0__dffrnq_1
XTAP_TAPCELL_ROW_1_219 VDD VSS gf180mcu_fd_sc_mcu7t5v0__filltie
X_2053_ _2053_/D _2187_/RN _2108_/CLK _2053_/Q VDD VDD VSS VSS gf180mcu_fd_sc_mcu7t5v0__dffrnq_1
XFILLER_47_492 VDD VDD VSS VSS gf180mcu_fd_sc_mcu7t5v0__fill_1
X_1004_ _2124_/D _2125_/D _2122_/D _2123_/D _1474_/C VDD VDD VSS VSS gf180mcu_fd_sc_mcu7t5v0__aoi22_1
XFILLER_50_613 VDD VDD VSS VSS gf180mcu_fd_sc_mcu7t5v0__fillcap_8
XTAP_TAPCELL_ROW_17_373 VDD VSS gf180mcu_fd_sc_mcu7t5v0__filltie
X_1906_ _1906_/D _1908_/RN _1961_/CLK _1906_/Q VDD VDD VSS VSS gf180mcu_fd_sc_mcu7t5v0__dffrnq_1
X_1837_ _1959_/Q _2084_/Q _1855_/S _2084_/D VDD VDD VSS VSS gf180mcu_fd_sc_mcu7t5v0__mux2_2
Xhold511 _2151_/Q _2147_/D VDD VDD VSS VSS gf180mcu_fd_sc_mcu7t5v0__dlyc_1
X_1768_ _1822_/B _1768_/A2 _1769_/A2 VDD VDD VSS VSS gf180mcu_fd_sc_mcu7t5v0__nand2_1
Xhold522 _2126_/Q _2127_/D VDD VDD VSS VSS gf180mcu_fd_sc_mcu7t5v0__dlyc_1
Xmax_cap230 _1453_/S _1452_/S VDD VDD VSS VSS gf180mcu_fd_sc_mcu7t5v0__clkbuf_1
X_1699_ _1699_/A1 _1835_/B1 _2053_/D VDD VDD VSS VSS gf180mcu_fd_sc_mcu7t5v0__nor2_1
XFILLER_85_543 VDD VDD VSS VSS gf180mcu_fd_sc_mcu7t5v0__fillcap_16
XFILLER_25_142 VDD VDD VSS VSS gf180mcu_fd_sc_mcu7t5v0__fillcap_16
XTAP_TAPCELL_ROW_84_1010 VDD VSS gf180mcu_fd_sc_mcu7t5v0__filltie
XTAP_TAPCELL_ROW_43_619 VDD VSS gf180mcu_fd_sc_mcu7t5v0__filltie
XFILLER_40_123 VDD VDD VSS VSS gf180mcu_fd_sc_mcu7t5v0__fill_2
XTAP_TAPCELL_ROW_51_696 VDD VSS gf180mcu_fd_sc_mcu7t5v0__filltie
XFILLER_21_392 VDD VDD VSS VSS gf180mcu_fd_sc_mcu7t5v0__fillcap_16
XFILLER_31_97 VDD VDD VSS VSS gf180mcu_fd_sc_mcu7t5v0__fill_2
XFILLER_5_558 VDD VDD VSS VSS gf180mcu_fd_sc_mcu7t5v0__fill_2
XTAP_TAPCELL_ROW_59_774 VDD VSS gf180mcu_fd_sc_mcu7t5v0__filltie
XFILLER_76_554 VDD VDD VSS VSS gf180mcu_fd_sc_mcu7t5v0__fillcap_16
XFILLER_91_535 VDD VDD VSS VSS gf180mcu_fd_sc_mcu7t5v0__fill_2
XFILLER_91_524 VDD VDD VSS VSS gf180mcu_fd_sc_mcu7t5v0__fill_2
XFILLER_29_492 VDD VDD VSS VSS gf180mcu_fd_sc_mcu7t5v0__fill_2
XFILLER_32_613 VDD VDD VSS VSS gf180mcu_fd_sc_mcu7t5v0__fill_2
XFILLER_44_473 VDD VDD VSS VSS gf180mcu_fd_sc_mcu7t5v0__fillcap_8
XTAP_TAPCELL_ROW_14_343 VDD VSS gf180mcu_fd_sc_mcu7t5v0__filltie
XFILLER_72_82 VDD VDD VSS VSS gf180mcu_fd_sc_mcu7t5v0__fillcap_16
XFILLER_12_370 VDD VDD VSS VSS gf180mcu_fd_sc_mcu7t5v0__fillcap_8
X_1622_ _1994_/Q input32/Z _1631_/S _1994_/D VDD VDD VSS VSS gf180mcu_fd_sc_mcu7t5v0__mux2_2
Xudma_uart_top_492 data_rx_o[16] VDD VDD VSS VSS gf180mcu_fd_sc_mcu7t5v0__tiel
Xudma_uart_top_481 cfg_tx_datasize_o[1] VDD VDD VSS VSS gf180mcu_fd_sc_mcu7t5v0__tiel
X_1553_ _1553_/A1 _1559_/A2 _1553_/B _1556_/A1 VDD VDD VSS VSS gf180mcu_fd_sc_mcu7t5v0__aoi21_1
X_1484_ _1511_/B _1462_/Z _1511_/C _1517_/A2 VDD VDD VSS VSS gf180mcu_fd_sc_mcu7t5v0__nand3_1
XFILLER_39_212 VDD VDD VSS VSS gf180mcu_fd_sc_mcu7t5v0__fillcap_4
X_2105_ _2105_/D _2187_/RN _2108_/CLK _2105_/Q VDD VDD VSS VSS gf180mcu_fd_sc_mcu7t5v0__dffrnq_1
XFILLER_94_373 VDD VDD VSS VSS gf180mcu_fd_sc_mcu7t5v0__fill_1
XFILLER_82_524 VDD VDD VSS VSS gf180mcu_fd_sc_mcu7t5v0__fill_1
XFILLER_39_278 VDD VDD VSS VSS gf180mcu_fd_sc_mcu7t5v0__fill_2
X_2036_ _2036_/D _2036_/RN _2037_/CLK _2106_/D VDD VDD VSS VSS gf180mcu_fd_sc_mcu7t5v0__dffrnq_1
XFILLER_22_101 VDD VDD VSS VSS gf180mcu_fd_sc_mcu7t5v0__fillcap_4
XFILLER_77_307 VDD VDD VSS VSS gf180mcu_fd_sc_mcu7t5v0__fill_1
XFILLER_98_690 VDD VDD VSS VSS gf180mcu_fd_sc_mcu7t5v0__fillcap_4
XTAP_TAPCELL_ROW_56_744 VDD VSS gf180mcu_fd_sc_mcu7t5v0__filltie
XTAP_TAPCELL_ROW_28_479 VDD VSS gf180mcu_fd_sc_mcu7t5v0__filltie
XFILLER_41_454 VDD VDD VSS VSS gf180mcu_fd_sc_mcu7t5v0__fill_2
XFILLER_13_178 VDD VDD VSS VSS gf180mcu_fd_sc_mcu7t5v0__fillcap_4
XTAP_TAPCELL_ROW_11_313 VDD VSS gf180mcu_fd_sc_mcu7t5v0__filltie
XFILLER_9_127 VDD VDD VSS VSS gf180mcu_fd_sc_mcu7t5v0__fill_1
XFILLER_42_41 VDD VDD VSS VSS gf180mcu_fd_sc_mcu7t5v0__fill_2
XFILLER_76_373 VDD VDD VSS VSS gf180mcu_fd_sc_mcu7t5v0__fillcap_8
XFILLER_64_535 VDD VDD VSS VSS gf180mcu_fd_sc_mcu7t5v0__fill_2
XFILLER_64_524 VDD VDD VSS VSS gf180mcu_fd_sc_mcu7t5v0__fill_1
X_0984_ _1893_/Q _1894_/Q _1059_/B VDD VDD VSS VSS gf180mcu_fd_sc_mcu7t5v0__nand2_1
XFILLER_73_2 VDD VDD VSS VSS gf180mcu_fd_sc_mcu7t5v0__fill_1
X_1605_ input6/Z _1978_/Q _1611_/S _1978_/D VDD VDD VSS VSS gf180mcu_fd_sc_mcu7t5v0__mux2_2
X_1536_ _1540_/A3 _1535_/Z _1539_/A1 VDD VDD VSS VSS gf180mcu_fd_sc_mcu7t5v0__nand2_1
X_1467_ _1466_/Z _1900_/Q _1473_/S _1900_/D VDD VDD VSS VSS gf180mcu_fd_sc_mcu7t5v0__mux2_2
X_1398_ input72/Z _1404_/A2 _1404_/B1 input42/Z _1399_/I VDD VDD VSS VSS gf180mcu_fd_sc_mcu7t5v0__aoi22_1
XTAP_TAPCELL_ROW_53_714 VDD VSS gf180mcu_fd_sc_mcu7t5v0__filltie
XFILLER_82_387 VDD VDD VSS VSS gf180mcu_fd_sc_mcu7t5v0__fill_2
XFILLER_70_527 VDD VDD VSS VSS gf180mcu_fd_sc_mcu7t5v0__fillcap_16
X_2019_ _2019_/D _2028_/RN _2037_/CLK _2019_/Q VDD VDD VSS VSS gf180mcu_fd_sc_mcu7t5v0__dffrnq_1
XTAP_TAPCELL_ROW_25_449 VDD VSS gf180mcu_fd_sc_mcu7t5v0__filltie
XFILLER_23_454 VDD VDD VSS VSS gf180mcu_fd_sc_mcu7t5v0__fillcap_16
XFILLER_11_627 VDD VDD VSS VSS gf180mcu_fd_sc_mcu7t5v0__fill_2
XFILLER_10_148 VDD VDD VSS VSS gf180mcu_fd_sc_mcu7t5v0__fillcap_4
XTAP_TAPCELL_ROW_61_791 VDD VSS gf180mcu_fd_sc_mcu7t5v0__filltie
XFILLER_7_609 VDD VDD VSS VSS gf180mcu_fd_sc_mcu7t5v0__fillcap_16
XFILLER_88_37 VDD VDD VSS VSS gf180mcu_fd_sc_mcu7t5v0__fillcap_64
XFILLER_92_107 VDD VDD VSS VSS gf180mcu_fd_sc_mcu7t5v0__fillcap_64
XFILLER_86_693 VDD VDD VSS VSS gf180mcu_fd_sc_mcu7t5v0__fill_1
XFILLER_58_384 VDD VDD VSS VSS gf180mcu_fd_sc_mcu7t5v0__fill_1
XFILLER_58_362 VDD VDD VSS VSS gf180mcu_fd_sc_mcu7t5v0__fillcap_16
XFILLER_46_535 VDD VDD VSS VSS gf180mcu_fd_sc_mcu7t5v0__fill_1
XFILLER_73_387 VDD VDD VSS VSS gf180mcu_fd_sc_mcu7t5v0__fillcap_16
XFILLER_14_454 VDD VDD VSS VSS gf180mcu_fd_sc_mcu7t5v0__fill_1
XFILLER_10_693 VDD VDD VSS VSS gf180mcu_fd_sc_mcu7t5v0__fill_1
XFILLER_6_675 VDD VDD VSS VSS gf180mcu_fd_sc_mcu7t5v0__fillcap_4
XFILLER_96_402 VDD VDD VSS VSS gf180mcu_fd_sc_mcu7t5v0__fill_2
X_1321_ _1396_/B1 input55/Z _1341_/A1 VDD VDD VSS VSS gf180mcu_fd_sc_mcu7t5v0__nand2_1
X_1252_ _1253_/A1 _1290_/A1 _1290_/A2 _1164_/I _2161_/D VDD VDD VSS VSS gf180mcu_fd_sc_mcu7t5v0__and4_1
XFILLER_77_682 VDD VDD VSS VSS gf180mcu_fd_sc_mcu7t5v0__fillcap_8
XFILLER_37_557 VDD VDD VSS VSS gf180mcu_fd_sc_mcu7t5v0__fill_2
X_1183_ _1191_/A1 _1963_/Q _1191_/A3 _1191_/A4 _1183_/Z VDD VDD VSS VSS gf180mcu_fd_sc_mcu7t5v0__and4_1
XFILLER_64_398 VDD VDD VSS VSS gf180mcu_fd_sc_mcu7t5v0__fillcap_32
XFILLER_64_387 VDD VDD VSS VSS gf180mcu_fd_sc_mcu7t5v0__fill_2
XTAP_TAPCELL_ROW_22_419 VDD VSS gf180mcu_fd_sc_mcu7t5v0__filltie
X_0967_ input1/Z input5/Z _1354_/A2 VDD VDD VSS VSS gf180mcu_fd_sc_mcu7t5v0__nor2_1
XTAP_TAPCELL_ROW_30_496 VDD VSS gf180mcu_fd_sc_mcu7t5v0__filltie
Xoutput210 _1308_/Z wire290/I VDD VDD VSS VSS gf180mcu_fd_sc_mcu7t5v0__buf_1
XPHY_EDGE_ROW_12_Right_12 VDD VSS gf180mcu_fd_sc_mcu7t5v0__endcap
X_1519_ _1525_/A1 _1519_/A2 _1519_/B _1923_/D VDD VDD VSS VSS gf180mcu_fd_sc_mcu7t5v0__oai21_1
XFILLER_87_457 VDD VDD VSS VSS gf180mcu_fd_sc_mcu7t5v0__fillcap_16
XFILLER_74_107 VDD VDD VSS VSS gf180mcu_fd_sc_mcu7t5v0__fill_1
XFILLER_68_693 VDD VDD VSS VSS gf180mcu_fd_sc_mcu7t5v0__fill_1
XFILLER_28_535 VDD VDD VSS VSS gf180mcu_fd_sc_mcu7t5v0__fillcap_8
XFILLER_67_170 VDD VDD VSS VSS gf180mcu_fd_sc_mcu7t5v0__fillcap_32
XPHY_EDGE_ROW_21_Right_21 VDD VSS gf180mcu_fd_sc_mcu7t5v0__endcap
XTAP_TAPCELL_ROW_38_574 VDD VSS gf180mcu_fd_sc_mcu7t5v0__filltie
XFILLER_70_313 VDD VDD VSS VSS gf180mcu_fd_sc_mcu7t5v0__fill_2
XFILLER_43_549 VDD VDD VSS VSS gf180mcu_fd_sc_mcu7t5v0__fillcap_8
XFILLER_23_262 VDD VDD VSS VSS gf180mcu_fd_sc_mcu7t5v0__fillcap_16
Xclkbuf_5_3__f_periph_clk_i clkbuf_4_1_0_periph_clk_i/Z _2108_/CLK VDD VDD VSS VSS
+ gf180mcu_fd_sc_mcu7t5v0__clkbuf_16
XFILLER_23_54 VDD VDD VSS VSS gf180mcu_fd_sc_mcu7t5v0__fillcap_16
Xwire304 wire304/I cfg_data_o[21] VDD VDD VSS VSS gf180mcu_fd_sc_mcu7t5v0__clkbuf_3
XFILLER_51_593 VDD VDD VSS VSS gf180mcu_fd_sc_mcu7t5v0__fill_2
XFILLER_7_439 VDD VDD VSS VSS gf180mcu_fd_sc_mcu7t5v0__fillcap_4
Xwire359 wire359/I cfg_tx_startaddr_o[4] VDD VDD VSS VSS gf180mcu_fd_sc_mcu7t5v0__clkbuf_3
XPHY_EDGE_ROW_30_Right_30 VDD VSS gf180mcu_fd_sc_mcu7t5v0__endcap
XFILLER_2_122 VDD VDD VSS VSS gf180mcu_fd_sc_mcu7t5v0__fill_1
XFILLER_3_2 VDD VDD VSS VSS gf180mcu_fd_sc_mcu7t5v0__fillcap_32
XFILLER_2_177 VDD VDD VSS VSS gf180mcu_fd_sc_mcu7t5v0__fillcap_4
Xfanout470 _2172_/RN _2067_/RN VDD VDD VSS VSS gf180mcu_fd_sc_mcu7t5v0__buf_1
XFILLER_65_129 VDD VDD VSS VSS gf180mcu_fd_sc_mcu7t5v0__fill_2
XFILLER_58_192 VDD VDD VSS VSS gf180mcu_fd_sc_mcu7t5v0__fill_1
XFILLER_46_321 VDD VDD VSS VSS gf180mcu_fd_sc_mcu7t5v0__fill_1
XFILLER_0_36 VDD VDD VSS VSS gf180mcu_fd_sc_mcu7t5v0__fillcap_4
XFILLER_34_505 VDD VDD VSS VSS gf180mcu_fd_sc_mcu7t5v0__fillcap_4
XFILLER_73_162 VDD VDD VSS VSS gf180mcu_fd_sc_mcu7t5v0__fillcap_4
XFILLER_61_302 VDD VDD VSS VSS gf180mcu_fd_sc_mcu7t5v0__fill_1
XFILLER_73_173 VDD VDD VSS VSS gf180mcu_fd_sc_mcu7t5v0__fillcap_8
XFILLER_46_387 VDD VDD VSS VSS gf180mcu_fd_sc_mcu7t5v0__fill_1
XFILLER_64_83 VDD VDD VSS VSS gf180mcu_fd_sc_mcu7t5v0__fillcap_16
XTAP_TAPCELL_ROW_72_897 VDD VSS gf180mcu_fd_sc_mcu7t5v0__filltie
X_1870_ _1870_/D _1886_/RN _2188_/CLK _1870_/Q VDD VDD VSS VSS gf180mcu_fd_sc_mcu7t5v0__dffrnq_1
XFILLER_80_82 VDD VDD VSS VSS gf180mcu_fd_sc_mcu7t5v0__fillcap_8
XFILLER_36_2 VDD VDD VSS VSS gf180mcu_fd_sc_mcu7t5v0__fillcap_8
XFILLER_69_413 VDD VDD VSS VSS gf180mcu_fd_sc_mcu7t5v0__fillcap_4
X_1304_ _1304_/A1 _1304_/A2 _1303_/Z _1304_/A4 _2176_/D VDD VDD VSS VSS gf180mcu_fd_sc_mcu7t5v0__and4_1
XFILLER_57_608 VDD VDD VSS VSS gf180mcu_fd_sc_mcu7t5v0__fill_1
XFILLER_56_107 VDD VDD VSS VSS gf180mcu_fd_sc_mcu7t5v0__fillcap_4
X_1235_ _2142_/Q _1243_/A4 _1237_/A2 VDD VDD VSS VSS gf180mcu_fd_sc_mcu7t5v0__nor2_1
X_1166_ _2155_/Q _2156_/Q _1415_/A4 VDD VDD VSS VSS gf180mcu_fd_sc_mcu7t5v0__nand2_1
XFILLER_92_482 VDD VDD VSS VSS gf180mcu_fd_sc_mcu7t5v0__fillcap_8
X_1097_ _2091_/Q _2167_/Q _1101_/A1 VDD VDD VSS VSS gf180mcu_fd_sc_mcu7t5v0__nand2_1
XTAP_TAPCELL_ROW_35_544 VDD VSS gf180mcu_fd_sc_mcu7t5v0__filltie
X_1999_ _1999_/D _1999_/RN _2128_/CLK _1999_/Q VDD VDD VSS VSS gf180mcu_fd_sc_mcu7t5v0__dffrnq_1
XFILLER_0_637 VDD VDD VSS VSS gf180mcu_fd_sc_mcu7t5v0__fillcap_8
XFILLER_0_648 VDD VDD VSS VSS gf180mcu_fd_sc_mcu7t5v0__fillcap_32
Xclkbuf_5_18__f_periph_clk_i clkbuf_4_9_0_periph_clk_i/Z _2157_/CLK VDD VDD VSS VSS
+ gf180mcu_fd_sc_mcu7t5v0__clkbuf_16
XFILLER_87_276 VDD VDD VSS VSS gf180mcu_fd_sc_mcu7t5v0__fillcap_4
XFILLER_75_405 VDD VDD VSS VSS gf180mcu_fd_sc_mcu7t5v0__fillcap_4
XFILLER_18_32 VDD VDD VSS VSS gf180mcu_fd_sc_mcu7t5v0__fill_2
XFILLER_28_310 VDD VDD VSS VSS gf180mcu_fd_sc_mcu7t5v0__fillcap_4
XTAP_TAPCELL_ROW_87_1041 VDD VSS gf180mcu_fd_sc_mcu7t5v0__filltie
XFILLER_16_527 VDD VDD VSS VSS gf180mcu_fd_sc_mcu7t5v0__fillcap_4
XFILLER_70_132 VDD VDD VSS VSS gf180mcu_fd_sc_mcu7t5v0__fill_1
XFILLER_71_688 VDD VDD VSS VSS gf180mcu_fd_sc_mcu7t5v0__fillcap_4
XFILLER_51_390 VDD VDD VSS VSS gf180mcu_fd_sc_mcu7t5v0__fill_2
XFILLER_3_442 VDD VDD VSS VSS gf180mcu_fd_sc_mcu7t5v0__fillcap_32
XFILLER_59_94 VDD VDD VSS VSS gf180mcu_fd_sc_mcu7t5v0__fill_1
XFILLER_59_72 VDD VDD VSS VSS gf180mcu_fd_sc_mcu7t5v0__fillcap_4
XFILLER_39_608 VDD VDD VSS VSS gf180mcu_fd_sc_mcu7t5v0__fill_1
XTAP_TAPCELL_ROW_77_945 VDD VSS gf180mcu_fd_sc_mcu7t5v0__filltie
X_1020_ _2100_/Q _2145_/Q _1020_/Z VDD VDD VSS VSS gf180mcu_fd_sc_mcu7t5v0__xor2_1
XFILLER_15_571 VDD VDD VSS VSS gf180mcu_fd_sc_mcu7t5v0__fill_1
XTAP_TAPCELL_ROW_32_514 VDD VSS gf180mcu_fd_sc_mcu7t5v0__filltie
XFILLER_30_541 VDD VDD VSS VSS gf180mcu_fd_sc_mcu7t5v0__fill_1
X_1922_ _1922_/D _1927_/RN _1961_/CLK _1922_/Q VDD VDD VSS VSS gf180mcu_fd_sc_mcu7t5v0__dffrnq_1
X_1853_ _1975_/Q _2100_/Q _1853_/S _2100_/D VDD VDD VSS VSS gf180mcu_fd_sc_mcu7t5v0__mux2_2
X_1784_ _1822_/B _1784_/A2 _1785_/A2 VDD VDD VSS VSS gf180mcu_fd_sc_mcu7t5v0__nand2_1
XTAP_TAPCELL_ROW_40_591 VDD VSS gf180mcu_fd_sc_mcu7t5v0__filltie
XFILLER_57_405 VDD VDD VSS VSS gf180mcu_fd_sc_mcu7t5v0__fillcap_8
X_1218_ _2134_/Q _2135_/Q _1205_/Z _1217_/Z _1218_/Z VDD VDD VSS VSS gf180mcu_fd_sc_mcu7t5v0__and4_1
X_1149_ _1149_/A1 _1149_/A2 _1149_/A3 _1149_/A4 _1150_/A3 VDD VDD VSS VSS gf180mcu_fd_sc_mcu7t5v0__nand4_1
XFILLER_0_412 VDD VDD VSS VSS gf180mcu_fd_sc_mcu7t5v0__fill_1
XFILLER_96_37 VDD VDD VSS VSS gf180mcu_fd_sc_mcu7t5v0__fillcap_64
XFILLER_0_478 VDD VDD VSS VSS gf180mcu_fd_sc_mcu7t5v0__fillcap_32
XFILLER_75_202 VDD VDD VSS VSS gf180mcu_fd_sc_mcu7t5v0__fill_2
XTAP_TAPCELL_ROW_74_915 VDD VSS gf180mcu_fd_sc_mcu7t5v0__filltie
XFILLER_45_96 VDD VDD VSS VSS gf180mcu_fd_sc_mcu7t5v0__fillcap_4
XFILLER_31_349 VDD VDD VSS VSS gf180mcu_fd_sc_mcu7t5v0__fill_1
XTAP_TAPCELL_ROW_82_992 VDD VSS gf180mcu_fd_sc_mcu7t5v0__filltie
XFILLER_43_198 VDD VDD VSS VSS gf180mcu_fd_sc_mcu7t5v0__fill_1
XFILLER_8_501 VDD VDD VSS VSS gf180mcu_fd_sc_mcu7t5v0__fillcap_16
XFILLER_61_51 VDD VDD VSS VSS gf180mcu_fd_sc_mcu7t5v0__fillcap_16
XTAP_TAPCELL_ROW_96_1129 VDD VSS gf180mcu_fd_sc_mcu7t5v0__filltie
XFILLER_8_567 VDD VDD VSS VSS gf180mcu_fd_sc_mcu7t5v0__fill_1
XFILLER_98_305 VDD VDD VSS VSS gf180mcu_fd_sc_mcu7t5v0__fill_1
X_2121_ _2125_/Q _2036_/RN _2125_/CLK _2121_/Q VDD VDD VSS VSS gf180mcu_fd_sc_mcu7t5v0__dffsnq_1
X_2052_ _2052_/D _2187_/RN _2061_/CLK _2052_/Q VDD VDD VSS VSS gf180mcu_fd_sc_mcu7t5v0__dffrnq_1
XFILLER_54_419 VDD VDD VSS VSS gf180mcu_fd_sc_mcu7t5v0__fillcap_16
X_1003_ _2123_/D _2125_/D _2124_/D _1475_/A3 VDD VDD VSS VSS gf180mcu_fd_sc_mcu7t5v0__oai21_1
XFILLER_22_349 VDD VDD VSS VSS gf180mcu_fd_sc_mcu7t5v0__fill_2
XTAP_TAPCELL_ROW_17_374 VDD VSS gf180mcu_fd_sc_mcu7t5v0__filltie
XFILLER_30_382 VDD VDD VSS VSS gf180mcu_fd_sc_mcu7t5v0__fill_2
X_1905_ _1905_/D _1951_/RN _1921_/CLK _1905_/Q VDD VDD VSS VSS gf180mcu_fd_sc_mcu7t5v0__dffrnq_1
X_1836_ _1958_/Q _2083_/Q _1855_/S _2083_/D VDD VDD VSS VSS gf180mcu_fd_sc_mcu7t5v0__mux2_2
XPHY_EDGE_ROW_6_Right_6 VDD VSS gf180mcu_fd_sc_mcu7t5v0__endcap
X_1767_ _1821_/A2 _1904_/Q _1896_/Q _1789_/A2 _1799_/C _1769_/A1 VDD VDD VSS VSS gf180mcu_fd_sc_mcu7t5v0__aoi221_1
Xhold512 _2103_/Q _2104_/D VDD VDD VSS VSS gf180mcu_fd_sc_mcu7t5v0__dlyc_1
Xhold523 _2109_/Q _2111_/D VDD VDD VSS VSS gf180mcu_fd_sc_mcu7t5v0__dlyc_1
X_1698_ _1705_/A1 _1698_/A2 _2053_/Q _1697_/C _1699_/A1 VDD VDD VSS VSS gf180mcu_fd_sc_mcu7t5v0__aoi22_1
Xmax_cap275 _1571_/S _1576_/S VDD VDD VSS VSS gf180mcu_fd_sc_mcu7t5v0__buf_2
XFILLER_89_349 VDD VDD VSS VSS gf180mcu_fd_sc_mcu7t5v0__fill_1
XFILLER_97_371 VDD VDD VSS VSS gf180mcu_fd_sc_mcu7t5v0__fillcap_4
XFILLER_57_268 VDD VDD VSS VSS gf180mcu_fd_sc_mcu7t5v0__fill_1
XFILLER_85_588 VDD VDD VSS VSS gf180mcu_fd_sc_mcu7t5v0__fill_2
XFILLER_57_279 VDD VDD VSS VSS gf180mcu_fd_sc_mcu7t5v0__fill_1
XFILLER_26_655 VDD VDD VSS VSS gf180mcu_fd_sc_mcu7t5v0__fill_1
XTAP_TAPCELL_ROW_84_1011 VDD VSS gf180mcu_fd_sc_mcu7t5v0__filltie
XFILLER_15_55 VDD VDD VSS VSS gf180mcu_fd_sc_mcu7t5v0__fillcap_8
XFILLER_15_88 VDD VDD VSS VSS gf180mcu_fd_sc_mcu7t5v0__fillcap_8
XTAP_TAPCELL_ROW_51_697 VDD VSS gf180mcu_fd_sc_mcu7t5v0__filltie
Xinput110 data_tx_valid_i _1580_/A3 VDD VDD VSS VSS gf180mcu_fd_sc_mcu7t5v0__dlyb_1
XFILLER_95_308 VDD VDD VSS VSS gf180mcu_fd_sc_mcu7t5v0__fill_2
XFILLER_88_382 VDD VDD VSS VSS gf180mcu_fd_sc_mcu7t5v0__fill_2
XFILLER_76_544 VDD VDD VSS VSS gf180mcu_fd_sc_mcu7t5v0__fill_1
XFILLER_48_257 VDD VDD VSS VSS gf180mcu_fd_sc_mcu7t5v0__fillcap_8
XTAP_TAPCELL_ROW_59_775 VDD VSS gf180mcu_fd_sc_mcu7t5v0__filltie
XFILLER_91_558 VDD VDD VSS VSS gf180mcu_fd_sc_mcu7t5v0__fill_2
XTAP_TAPCELL_ROW_14_344 VDD VSS gf180mcu_fd_sc_mcu7t5v0__filltie
XFILLER_12_360 VDD VDD VSS VSS gf180mcu_fd_sc_mcu7t5v0__fill_1
XFILLER_12_382 VDD VDD VSS VSS gf180mcu_fd_sc_mcu7t5v0__fill_2
XPHY_EDGE_ROW_59_Right_59 VDD VSS gf180mcu_fd_sc_mcu7t5v0__endcap
X_1621_ _1993_/Q input31/Z _1621_/S _1993_/D VDD VDD VSS VSS gf180mcu_fd_sc_mcu7t5v0__mux2_2
Xudma_uart_top_493 data_rx_o[17] VDD VDD VSS VSS gf180mcu_fd_sc_mcu7t5v0__tiel
Xudma_uart_top_482 data_rx_datasize_o[0] VDD VDD VSS VSS gf180mcu_fd_sc_mcu7t5v0__tiel
X_1552_ _1936_/Q _1937_/Q _1553_/B VDD VDD VSS VSS gf180mcu_fd_sc_mcu7t5v0__xor2_1
X_1483_ _1499_/A1 _1906_/Q _1485_/B VDD VDD VSS VSS gf180mcu_fd_sc_mcu7t5v0__nand2_1
XFILLER_4_592 VDD VDD VSS VSS gf180mcu_fd_sc_mcu7t5v0__fill_2
XPHY_EDGE_ROW_68_Right_68 VDD VSS gf180mcu_fd_sc_mcu7t5v0__endcap
XFILLER_39_224 VDD VDD VSS VSS gf180mcu_fd_sc_mcu7t5v0__fillcap_8
X_2104_ _2104_/D _2108_/RN _2187_/CLK _2105_/D VDD VDD VSS VSS gf180mcu_fd_sc_mcu7t5v0__dffrnq_1
XFILLER_94_341 VDD VDD VSS VSS gf180mcu_fd_sc_mcu7t5v0__fill_1
X_2035_ _2035_/D _2115_/RN _2153_/CLK _2035_/Q VDD VDD VSS VSS gf180mcu_fd_sc_mcu7t5v0__dffrnq_1
XFILLER_23_647 VDD VDD VSS VSS gf180mcu_fd_sc_mcu7t5v0__fill_1
XPHY_EDGE_ROW_77_Right_77 VDD VSS gf180mcu_fd_sc_mcu7t5v0__endcap
X_1819_ _1935_/Q _1933_/Q _1927_/Q _1820_/A2 _1932_/Q _1822_/A2 VDD VDD VSS VSS gf180mcu_fd_sc_mcu7t5v0__oai221_1
XPHY_EDGE_ROW_86_Right_86 VDD VSS gf180mcu_fd_sc_mcu7t5v0__endcap
XTAP_TAPCELL_ROW_90_1070 VDD VSS gf180mcu_fd_sc_mcu7t5v0__filltie
XTAP_TAPCELL_ROW_56_745 VDD VSS gf180mcu_fd_sc_mcu7t5v0__filltie
XFILLER_73_558 VDD VDD VSS VSS gf180mcu_fd_sc_mcu7t5v0__fill_2
XFILLER_26_452 VDD VDD VSS VSS gf180mcu_fd_sc_mcu7t5v0__fill_2
XPHY_EDGE_ROW_95_Right_95 VDD VSS gf180mcu_fd_sc_mcu7t5v0__endcap
XFILLER_41_422 VDD VDD VSS VSS gf180mcu_fd_sc_mcu7t5v0__fillcap_32
XFILLER_22_680 VDD VDD VSS VSS gf180mcu_fd_sc_mcu7t5v0__fill_2
XTAP_TAPCELL_ROW_11_314 VDD VSS gf180mcu_fd_sc_mcu7t5v0__filltie
XFILLER_5_334 VDD VDD VSS VSS gf180mcu_fd_sc_mcu7t5v0__fill_1
XFILLER_1_562 VDD VDD VSS VSS gf180mcu_fd_sc_mcu7t5v0__fillcap_64
XFILLER_89_680 VDD VDD VSS VSS gf180mcu_fd_sc_mcu7t5v0__fillcap_8
XFILLER_67_72 VDD VDD VSS VSS gf180mcu_fd_sc_mcu7t5v0__fillcap_64
XFILLER_17_430 VDD VDD VSS VSS gf180mcu_fd_sc_mcu7t5v0__fillcap_16
XFILLER_91_388 VDD VDD VSS VSS gf180mcu_fd_sc_mcu7t5v0__fill_1
XFILLER_51_208 VDD VDD VSS VSS gf180mcu_fd_sc_mcu7t5v0__fill_2
XFILLER_72_580 VDD VDD VSS VSS gf180mcu_fd_sc_mcu7t5v0__fillcap_4
XFILLER_13_680 VDD VDD VSS VSS gf180mcu_fd_sc_mcu7t5v0__fillcap_8
X_0983_ input1/Z input33/Z _0983_/A3 _1673_/A4 _2116_/D VDD VDD VSS VSS gf180mcu_fd_sc_mcu7t5v0__and4_1
XFILLER_66_2 VDD VDD VSS VSS gf180mcu_fd_sc_mcu7t5v0__fill_2
X_1604_ _1673_/A3 _1604_/A2 _1604_/A3 _1604_/A4 _1609_/S VDD VDD VSS VSS gf180mcu_fd_sc_mcu7t5v0__nand4_1
X_1535_ _1535_/A1 _2120_/Q _1535_/A3 _1535_/Z VDD VDD VSS VSS gf180mcu_fd_sc_mcu7t5v0__or3_1
X_1466_ _1944_/Q _1952_/Q _1939_/Q _1466_/Z VDD VDD VSS VSS gf180mcu_fd_sc_mcu7t5v0__mux2_2
X_1397_ _1397_/A1 _1397_/A2 _1397_/ZN VDD VDD VSS VSS gf180mcu_fd_sc_mcu7t5v0__nand2_1
XFILLER_94_171 VDD VDD VSS VSS gf180mcu_fd_sc_mcu7t5v0__fillcap_4
X_2018_ _2018_/D _2018_/RN _2018_/CLK _2018_/Q VDD VDD VSS VSS gf180mcu_fd_sc_mcu7t5v0__dffrnq_1
XTAP_TAPCELL_ROW_53_715 VDD VSS gf180mcu_fd_sc_mcu7t5v0__filltie
XFILLER_23_422 VDD VDD VSS VSS gf180mcu_fd_sc_mcu7t5v0__fillcap_32
XFILLER_35_271 VDD VDD VSS VSS gf180mcu_fd_sc_mcu7t5v0__fillcap_8
XFILLER_35_282 VDD VDD VSS VSS gf180mcu_fd_sc_mcu7t5v0__fillcap_16
XFILLER_50_241 VDD VDD VSS VSS gf180mcu_fd_sc_mcu7t5v0__fillcap_4
XTAP_TAPCELL_ROW_61_792 VDD VSS gf180mcu_fd_sc_mcu7t5v0__filltie
XFILLER_12_34 VDD VDD VSS VSS gf180mcu_fd_sc_mcu7t5v0__fill_1
XTAP_TAPCELL_ROW_69_870 VDD VSS gf180mcu_fd_sc_mcu7t5v0__filltie
XFILLER_86_683 VDD VDD VSS VSS gf180mcu_fd_sc_mcu7t5v0__fillcap_8
XFILLER_86_661 VDD VDD VSS VSS gf180mcu_fd_sc_mcu7t5v0__fillcap_4
XFILLER_73_322 VDD VDD VSS VSS gf180mcu_fd_sc_mcu7t5v0__fillcap_16
XFILLER_33_208 VDD VDD VSS VSS gf180mcu_fd_sc_mcu7t5v0__fill_2
XFILLER_10_661 VDD VDD VSS VSS gf180mcu_fd_sc_mcu7t5v0__fillcap_4
XFILLER_10_683 VDD VDD VSS VSS gf180mcu_fd_sc_mcu7t5v0__fillcap_8
XFILLER_5_142 VDD VDD VSS VSS gf180mcu_fd_sc_mcu7t5v0__fillcap_4
X_1320_ _1320_/A1 _1319_/C _1319_/B _1396_/B1 VDD VDD VSS VSS gf180mcu_fd_sc_mcu7t5v0__nand3_1
XFILLER_96_425 VDD VDD VSS VSS gf180mcu_fd_sc_mcu7t5v0__fillcap_4
X_1251_ _1251_/A1 _1251_/A2 _1251_/B _1304_/A1 VDD VDD VSS VSS gf180mcu_fd_sc_mcu7t5v0__aoi21_1
XFILLER_84_609 VDD VDD VSS VSS gf180mcu_fd_sc_mcu7t5v0__fillcap_8
XFILLER_49_341 VDD VDD VSS VSS gf180mcu_fd_sc_mcu7t5v0__fill_2
XFILLER_37_525 VDD VDD VSS VSS gf180mcu_fd_sc_mcu7t5v0__fillcap_16
X_1182_ _1191_/A1 _1962_/Q _1191_/A3 _1195_/A4 _1182_/Z VDD VDD VSS VSS gf180mcu_fd_sc_mcu7t5v0__and4_1
XFILLER_49_352 VDD VDD VSS VSS gf180mcu_fd_sc_mcu7t5v0__fillcap_16
XFILLER_76_193 VDD VDD VSS VSS gf180mcu_fd_sc_mcu7t5v0__fill_2
XFILLER_76_171 VDD VDD VSS VSS gf180mcu_fd_sc_mcu7t5v0__fillcap_4
XFILLER_64_311 VDD VDD VSS VSS gf180mcu_fd_sc_mcu7t5v0__fillcap_4
XFILLER_20_403 VDD VDD VSS VSS gf180mcu_fd_sc_mcu7t5v0__fill_1
X_0966_ _0966_/A1 _2116_/Q _1883_/RN VDD VDD VSS VSS gf180mcu_fd_sc_mcu7t5v0__nor2_1
Xclkbuf_5_26__f_periph_clk_i clkbuf_4_13_0_periph_clk_i/Z _2171_/CLK VDD VDD VSS VSS
+ gf180mcu_fd_sc_mcu7t5v0__clkbuf_16
XTAP_TAPCELL_ROW_30_497 VDD VSS gf180mcu_fd_sc_mcu7t5v0__filltie
XFILLER_9_492 VDD VDD VSS VSS gf180mcu_fd_sc_mcu7t5v0__fillcap_8
Xoutput200 _2010_/Q wire360/I VDD VDD VSS VSS gf180mcu_fd_sc_mcu7t5v0__buf_1
Xoutput211 _1309_/Z wire289/I VDD VDD VSS VSS gf180mcu_fd_sc_mcu7t5v0__buf_1
X_1518_ _1524_/A1 _1923_/Q _1519_/B VDD VDD VSS VSS gf180mcu_fd_sc_mcu7t5v0__nand2_1
X_1449_ _1685_/A1 _1446_/Z _1449_/B _1449_/C wire233/I VDD VDD VSS VSS gf180mcu_fd_sc_mcu7t5v0__aoi211_1
XFILLER_59_138 VDD VDD VSS VSS gf180mcu_fd_sc_mcu7t5v0__fill_2
XFILLER_68_683 VDD VDD VSS VSS gf180mcu_fd_sc_mcu7t5v0__fillcap_8
XFILLER_68_661 VDD VDD VSS VSS gf180mcu_fd_sc_mcu7t5v0__fillcap_4
XFILLER_67_160 VDD VDD VSS VSS gf180mcu_fd_sc_mcu7t5v0__fill_2
XFILLER_28_547 VDD VDD VSS VSS gf180mcu_fd_sc_mcu7t5v0__fill_2
XTAP_TAPCELL_ROW_66_840 VDD VSS gf180mcu_fd_sc_mcu7t5v0__filltie
XFILLER_83_620 VDD VDD VSS VSS gf180mcu_fd_sc_mcu7t5v0__fillcap_8
XFILLER_74_18 VDD VDD VSS VSS gf180mcu_fd_sc_mcu7t5v0__fillcap_16
XFILLER_55_322 VDD VDD VSS VSS gf180mcu_fd_sc_mcu7t5v0__fill_2
XFILLER_83_664 VDD VDD VSS VSS gf180mcu_fd_sc_mcu7t5v0__fillcap_16
XFILLER_70_303 VDD VDD VSS VSS gf180mcu_fd_sc_mcu7t5v0__fill_1
XFILLER_55_344 VDD VDD VSS VSS gf180mcu_fd_sc_mcu7t5v0__fill_1
XTAP_TAPCELL_ROW_38_575 VDD VSS gf180mcu_fd_sc_mcu7t5v0__filltie
XFILLER_82_174 VDD VDD VSS VSS gf180mcu_fd_sc_mcu7t5v0__fill_1
XFILLER_11_403 VDD VDD VSS VSS gf180mcu_fd_sc_mcu7t5v0__fill_2
XFILLER_11_414 VDD VDD VSS VSS gf180mcu_fd_sc_mcu7t5v0__fill_1
XFILLER_23_22 VDD VDD VSS VSS gf180mcu_fd_sc_mcu7t5v0__fillcap_32
Xwire305 wire305/I cfg_data_o[20] VDD VDD VSS VSS gf180mcu_fd_sc_mcu7t5v0__clkbuf_3
XFILLER_2_167 VDD VDD VSS VSS gf180mcu_fd_sc_mcu7t5v0__fill_2
Xclkbuf_0_periph_clk_i periph_clk_i clkbuf_0_periph_clk_i/Z VDD VDD VSS VSS gf180mcu_fd_sc_mcu7t5v0__clkbuf_16
Xfanout460 _1927_/RN _1908_/RN VDD VDD VSS VSS gf180mcu_fd_sc_mcu7t5v0__dlyb_1
Xfanout471 _2172_/RN _2160_/RN VDD VDD VSS VSS gf180mcu_fd_sc_mcu7t5v0__dlyb_1
XFILLER_93_417 VDD VDD VSS VSS gf180mcu_fd_sc_mcu7t5v0__fill_2
XFILLER_48_96 VDD VDD VSS VSS gf180mcu_fd_sc_mcu7t5v0__fillcap_8
XPHY_EDGE_ROW_14_Left_113 VDD VSS gf180mcu_fd_sc_mcu7t5v0__endcap
XFILLER_73_185 VDD VDD VSS VSS gf180mcu_fd_sc_mcu7t5v0__fill_2
XTAP_TAPCELL_ROW_72_898 VDD VSS gf180mcu_fd_sc_mcu7t5v0__filltie
XFILLER_42_594 VDD VDD VSS VSS gf180mcu_fd_sc_mcu7t5v0__fill_1
XFILLER_80_94 VDD VDD VSS VSS gf180mcu_fd_sc_mcu7t5v0__fill_2
XFILLER_6_451 VDD VDD VSS VSS gf180mcu_fd_sc_mcu7t5v0__fillcap_4
XPHY_EDGE_ROW_23_Left_122 VDD VSS gf180mcu_fd_sc_mcu7t5v0__endcap
X_1303_ _1303_/A1 _1156_/B _1303_/A3 _1303_/Z VDD VDD VSS VSS gf180mcu_fd_sc_mcu7t5v0__or3_1
X_1234_ _1247_/A1 _1234_/A2 _1243_/A4 _2141_/D VDD VDD VSS VSS gf180mcu_fd_sc_mcu7t5v0__nor3_1
XFILLER_96_299 VDD VDD VSS VSS gf180mcu_fd_sc_mcu7t5v0__fill_1
XFILLER_49_171 VDD VDD VSS VSS gf180mcu_fd_sc_mcu7t5v0__fillcap_16
X_1165_ _1290_/A1 _1290_/A2 _1251_/B _2160_/D VDD VDD VSS VSS gf180mcu_fd_sc_mcu7t5v0__aoi21_1
XPHY_EDGE_ROW_32_Left_131 VDD VSS gf180mcu_fd_sc_mcu7t5v0__endcap
XFILLER_92_450 VDD VDD VSS VSS gf180mcu_fd_sc_mcu7t5v0__fillcap_4
XFILLER_65_664 VDD VDD VSS VSS gf180mcu_fd_sc_mcu7t5v0__fillcap_16
X_1096_ _1096_/A1 _1096_/A2 _1096_/B1 _1095_/Z _1108_/A2 VDD VDD VSS VSS gf180mcu_fd_sc_mcu7t5v0__aoi22_1
XTAP_TAPCELL_ROW_63_810 VDD VSS gf180mcu_fd_sc_mcu7t5v0__filltie
XFILLER_92_494 VDD VDD VSS VSS gf180mcu_fd_sc_mcu7t5v0__fill_1
XFILLER_64_185 VDD VDD VSS VSS gf180mcu_fd_sc_mcu7t5v0__fill_1
XFILLER_52_325 VDD VDD VSS VSS gf180mcu_fd_sc_mcu7t5v0__fillcap_4
XFILLER_52_303 VDD VDD VSS VSS gf180mcu_fd_sc_mcu7t5v0__fill_2
XTAP_TAPCELL_ROW_35_545 VDD VSS gf180mcu_fd_sc_mcu7t5v0__filltie
XFILLER_80_667 VDD VDD VSS VSS gf180mcu_fd_sc_mcu7t5v0__fillcap_16
XFILLER_33_594 VDD VDD VSS VSS gf180mcu_fd_sc_mcu7t5v0__fillcap_16
XFILLER_20_244 VDD VDD VSS VSS gf180mcu_fd_sc_mcu7t5v0__fill_1
X_1998_ _1998_/D _2127_/RN _2128_/CLK _1998_/Q VDD VDD VSS VSS gf180mcu_fd_sc_mcu7t5v0__dffrnq_1
X_0949_ _2188_/Q _1169_/B1 VDD VDD VSS VSS gf180mcu_fd_sc_mcu7t5v0__clkinv_1
XPHY_EDGE_ROW_41_Left_140 VDD VSS gf180mcu_fd_sc_mcu7t5v0__endcap
XFILLER_69_18 VDD VDD VSS VSS gf180mcu_fd_sc_mcu7t5v0__fillcap_32
XFILLER_0_616 VDD VDD VSS VSS gf180mcu_fd_sc_mcu7t5v0__fill_1
XFILLER_87_288 VDD VDD VSS VSS gf180mcu_fd_sc_mcu7t5v0__fill_1
XFILLER_75_428 VDD VDD VSS VSS gf180mcu_fd_sc_mcu7t5v0__fillcap_32
XTAP_TAPCELL_ROW_87_1042 VDD VSS gf180mcu_fd_sc_mcu7t5v0__filltie
XFILLER_55_152 VDD VDD VSS VSS gf180mcu_fd_sc_mcu7t5v0__fillcap_4
XFILLER_43_347 VDD VDD VSS VSS gf180mcu_fd_sc_mcu7t5v0__fill_2
XFILLER_43_336 VDD VDD VSS VSS gf180mcu_fd_sc_mcu7t5v0__fill_2
XFILLER_70_177 VDD VDD VSS VSS gf180mcu_fd_sc_mcu7t5v0__fill_1
XFILLER_70_166 VDD VDD VSS VSS gf180mcu_fd_sc_mcu7t5v0__fillcap_8
XFILLER_70_155 VDD VDD VSS VSS gf180mcu_fd_sc_mcu7t5v0__fillcap_4
XFILLER_50_97 VDD VDD VSS VSS gf180mcu_fd_sc_mcu7t5v0__fill_2
XFILLER_78_244 VDD VDD VSS VSS gf180mcu_fd_sc_mcu7t5v0__fill_1
XTAP_TAPCELL_ROW_6_270 VDD VSS gf180mcu_fd_sc_mcu7t5v0__filltie
XTAP_TAPCELL_ROW_77_946 VDD VSS gf180mcu_fd_sc_mcu7t5v0__filltie
XFILLER_59_480 VDD VDD VSS VSS gf180mcu_fd_sc_mcu7t5v0__fillcap_8
XFILLER_75_72 VDD VDD VSS VSS gf180mcu_fd_sc_mcu7t5v0__fillcap_32
XFILLER_46_130 VDD VDD VSS VSS gf180mcu_fd_sc_mcu7t5v0__fillcap_16
XFILLER_19_377 VDD VDD VSS VSS gf180mcu_fd_sc_mcu7t5v0__fillcap_8
XFILLER_46_185 VDD VDD VSS VSS gf180mcu_fd_sc_mcu7t5v0__fillcap_8
XFILLER_46_174 VDD VDD VSS VSS gf180mcu_fd_sc_mcu7t5v0__fill_1
XFILLER_34_336 VDD VDD VSS VSS gf180mcu_fd_sc_mcu7t5v0__fill_2
XFILLER_62_667 VDD VDD VSS VSS gf180mcu_fd_sc_mcu7t5v0__fillcap_16
X_1921_ _1921_/D _1927_/RN _1921_/CLK _1921_/Q VDD VDD VSS VSS gf180mcu_fd_sc_mcu7t5v0__dffrnq_1
XTAP_TAPCELL_ROW_32_515 VDD VSS gf180mcu_fd_sc_mcu7t5v0__filltie
X_1852_ _1974_/Q _2099_/Q _1853_/S _2099_/D VDD VDD VSS VSS gf180mcu_fd_sc_mcu7t5v0__mux2_2
X_1783_ _1821_/A2 _1906_/Q _1898_/Q _1789_/A2 _1799_/C _1785_/A1 VDD VDD VSS VSS gf180mcu_fd_sc_mcu7t5v0__aoi221_1
XTAP_TAPCELL_ROW_40_592 VDD VSS gf180mcu_fd_sc_mcu7t5v0__filltie
XFILLER_69_244 VDD VDD VSS VSS gf180mcu_fd_sc_mcu7t5v0__fill_2
XFILLER_57_417 VDD VDD VSS VSS gf180mcu_fd_sc_mcu7t5v0__fill_2
X_1217_ _2136_/Q _2137_/Q _1217_/Z VDD VDD VSS VSS gf180mcu_fd_sc_mcu7t5v0__and2_1
XFILLER_84_247 VDD VDD VSS VSS gf180mcu_fd_sc_mcu7t5v0__fillcap_8
XTAP_TAPCELL_ROW_48_670 VDD VSS gf180mcu_fd_sc_mcu7t5v0__filltie
X_1148_ _1148_/A1 _2161_/Q _1270_/A1 _2090_/Q _1149_/A3 VDD VDD VSS VSS gf180mcu_fd_sc_mcu7t5v0__aoi22_1
X_1079_ _1141_/B2 _2174_/Q _1253_/A2 _2086_/Q _1080_/A4 VDD VDD VSS VSS gf180mcu_fd_sc_mcu7t5v0__aoi22_1
XFILLER_52_177 VDD VDD VSS VSS gf180mcu_fd_sc_mcu7t5v0__fill_2
XFILLER_40_317 VDD VDD VSS VSS gf180mcu_fd_sc_mcu7t5v0__fillcap_8
XFILLER_21_553 VDD VDD VSS VSS gf180mcu_fd_sc_mcu7t5v0__fillcap_4
XFILLER_0_435 VDD VDD VSS VSS gf180mcu_fd_sc_mcu7t5v0__fill_1
XFILLER_88_520 VDD VDD VSS VSS gf180mcu_fd_sc_mcu7t5v0__fillcap_4
XFILLER_88_597 VDD VDD VSS VSS gf180mcu_fd_sc_mcu7t5v0__fillcap_64
XTAP_TAPCELL_ROW_74_916 VDD VSS gf180mcu_fd_sc_mcu7t5v0__filltie
XTAP_TAPCELL_ROW_3_240 VDD VSS gf180mcu_fd_sc_mcu7t5v0__filltie
XFILLER_63_409 VDD VDD VSS VSS gf180mcu_fd_sc_mcu7t5v0__fill_2
XFILLER_16_314 VDD VDD VSS VSS gf180mcu_fd_sc_mcu7t5v0__fill_1
XFILLER_44_667 VDD VDD VSS VSS gf180mcu_fd_sc_mcu7t5v0__fill_2
XTAP_TAPCELL_ROW_82_993 VDD VSS gf180mcu_fd_sc_mcu7t5v0__filltie
XFILLER_24_391 VDD VDD VSS VSS gf180mcu_fd_sc_mcu7t5v0__fill_2
XFILLER_12_597 VDD VDD VSS VSS gf180mcu_fd_sc_mcu7t5v0__fillcap_64
XFILLER_61_96 VDD VDD VSS VSS gf180mcu_fd_sc_mcu7t5v0__fill_2
XFILLER_6_69 VDD VDD VSS VSS gf180mcu_fd_sc_mcu7t5v0__fillcap_4
X_2120_ _2124_/Q _2036_/RN _2125_/CLK _2120_/Q VDD VDD VSS VSS gf180mcu_fd_sc_mcu7t5v0__dffsnq_1
XFILLER_94_523 VDD VDD VSS VSS gf180mcu_fd_sc_mcu7t5v0__fill_2
X_2051_ _2051_/D _2051_/RN _2153_/CLK _2051_/Q VDD VDD VSS VSS gf180mcu_fd_sc_mcu7t5v0__dffrnq_1
XFILLER_66_247 VDD VDD VSS VSS gf180mcu_fd_sc_mcu7t5v0__fillcap_16
XFILLER_34_100 VDD VDD VSS VSS gf180mcu_fd_sc_mcu7t5v0__fillcap_4
X_1002_ _2124_/D _2123_/D _1474_/B VDD VDD VSS VSS gf180mcu_fd_sc_mcu7t5v0__and2_1
XFILLER_81_228 VDD VDD VSS VSS gf180mcu_fd_sc_mcu7t5v0__fillcap_8
XFILLER_47_472 VDD VDD VSS VSS gf180mcu_fd_sc_mcu7t5v0__fillcap_16
XFILLER_19_196 VDD VDD VSS VSS gf180mcu_fd_sc_mcu7t5v0__fillcap_8
XTAP_TAPCELL_ROW_45_640 VDD VSS gf180mcu_fd_sc_mcu7t5v0__filltie
XFILLER_22_317 VDD VDD VSS VSS gf180mcu_fd_sc_mcu7t5v0__fillcap_8
XFILLER_34_177 VDD VDD VSS VSS gf180mcu_fd_sc_mcu7t5v0__fillcap_8
XTAP_TAPCELL_ROW_17_375 VDD VSS gf180mcu_fd_sc_mcu7t5v0__filltie
X_1904_ _1904_/D _1954_/RN _1955_/CLK _1904_/Q VDD VDD VSS VSS gf180mcu_fd_sc_mcu7t5v0__dffrnq_1
X_1835_ _1753_/C _2108_/D _1835_/B1 _2105_/D _1835_/ZN VDD VDD VSS VSS gf180mcu_fd_sc_mcu7t5v0__aoi22_1
X_1766_ _1799_/C _1766_/A2 _1766_/A3 _1768_/A2 VDD VDD VSS VSS gf180mcu_fd_sc_mcu7t5v0__nand3_1
Xhold513 _2150_/Q _2146_/D VDD VDD VSS VSS gf180mcu_fd_sc_mcu7t5v0__dlyc_1
Xhold524 _2154_/Q _2155_/D VDD VDD VSS VSS gf180mcu_fd_sc_mcu7t5v0__dlyc_1
Xmax_cap232 _1450_/S _1451_/S VDD VDD VSS VSS gf180mcu_fd_sc_mcu7t5v0__clkbuf_1
X_1697_ _1728_/A1 _1700_/A2 _1697_/B1 _1064_/I _1697_/C _1704_/A2 VDD VDD VSS VSS
+ gf180mcu_fd_sc_mcu7t5v0__aoi221_1
Xmax_cap276 _1573_/S _1571_/S VDD VDD VSS VSS gf180mcu_fd_sc_mcu7t5v0__buf_2
Xmax_cap265 _1645_/S _1642_/S VDD VDD VSS VSS gf180mcu_fd_sc_mcu7t5v0__clkbuf_1
XFILLER_26_601 VDD VDD VSS VSS gf180mcu_fd_sc_mcu7t5v0__fill_1
XTAP_TAPCELL_ROW_0_210 VDD VSS gf180mcu_fd_sc_mcu7t5v0__filltie
XTAP_TAPCELL_ROW_84_1012 VDD VSS gf180mcu_fd_sc_mcu7t5v0__filltie
XFILLER_25_166 VDD VDD VSS VSS gf180mcu_fd_sc_mcu7t5v0__fillcap_4
XFILLER_15_67 VDD VDD VSS VSS gf180mcu_fd_sc_mcu7t5v0__fill_2
XFILLER_21_372 VDD VDD VSS VSS gf180mcu_fd_sc_mcu7t5v0__fillcap_8
XTAP_TAPCELL_ROW_51_698 VDD VSS gf180mcu_fd_sc_mcu7t5v0__filltie
XFILLER_5_538 VDD VDD VSS VSS gf180mcu_fd_sc_mcu7t5v0__fillcap_16
Xinput100 data_rx_ready_i _1448_/A3 VDD VDD VSS VSS gf180mcu_fd_sc_mcu7t5v0__dlyb_1
Xinput111 rstn_i input111/Z VDD VDD VSS VSS gf180mcu_fd_sc_mcu7t5v0__dlyb_1
XFILLER_76_534 VDD VDD VSS VSS gf180mcu_fd_sc_mcu7t5v0__fill_1
XFILLER_48_269 VDD VDD VSS VSS gf180mcu_fd_sc_mcu7t5v0__fill_2
XFILLER_48_247 VDD VDD VSS VSS gf180mcu_fd_sc_mcu7t5v0__fillcap_4
XFILLER_48_236 VDD VDD VSS VSS gf180mcu_fd_sc_mcu7t5v0__fillcap_8
XTAP_TAPCELL_ROW_59_776 VDD VSS gf180mcu_fd_sc_mcu7t5v0__filltie
XFILLER_29_494 VDD VDD VSS VSS gf180mcu_fd_sc_mcu7t5v0__fill_1
XFILLER_16_155 VDD VDD VSS VSS gf180mcu_fd_sc_mcu7t5v0__fillcap_8
XTAP_TAPCELL_ROW_42_610 VDD VSS gf180mcu_fd_sc_mcu7t5v0__filltie
XFILLER_31_158 VDD VDD VSS VSS gf180mcu_fd_sc_mcu7t5v0__fillcap_8
XTAP_TAPCELL_ROW_14_345 VDD VSS gf180mcu_fd_sc_mcu7t5v0__filltie
XFILLER_8_321 VDD VDD VSS VSS gf180mcu_fd_sc_mcu7t5v0__fill_1
XFILLER_8_332 VDD VDD VSS VSS gf180mcu_fd_sc_mcu7t5v0__fill_1
X_1620_ _1992_/Q input28/Z _1621_/S _1992_/D VDD VDD VSS VSS gf180mcu_fd_sc_mcu7t5v0__mux2_2
XFILLER_8_387 VDD VDD VSS VSS gf180mcu_fd_sc_mcu7t5v0__fill_2
XFILLER_8_376 VDD VDD VSS VSS gf180mcu_fd_sc_mcu7t5v0__fillcap_8
Xudma_uart_top_494 data_rx_o[18] VDD VDD VSS VSS gf180mcu_fd_sc_mcu7t5v0__tiel
Xudma_uart_top_483 data_rx_datasize_o[1] VDD VDD VSS VSS gf180mcu_fd_sc_mcu7t5v0__tiel
X_1551_ _1936_/Q _1550_/B _1553_/A1 _1936_/D VDD VDD VSS VSS gf180mcu_fd_sc_mcu7t5v0__xor3_1
X_1482_ _1510_/A2 _1515_/A2 _1482_/B _1905_/D VDD VDD VSS VSS gf180mcu_fd_sc_mcu7t5v0__oai21_1
XFILLER_11_2 VDD VDD VSS VSS gf180mcu_fd_sc_mcu7t5v0__fillcap_64
X_2103_ _2103_/D _2108_/RN _2187_/CLK _2103_/Q VDD VDD VSS VSS gf180mcu_fd_sc_mcu7t5v0__dffrnq_1
XFILLER_67_545 VDD VDD VSS VSS gf180mcu_fd_sc_mcu7t5v0__fill_1
XPHY_EDGE_ROW_6_Left_105 VDD VSS gf180mcu_fd_sc_mcu7t5v0__endcap
XFILLER_82_504 VDD VDD VSS VSS gf180mcu_fd_sc_mcu7t5v0__fillcap_16
X_2034_ _2034_/D _2034_/RN _2034_/CLK _2034_/Q VDD VDD VSS VSS gf180mcu_fd_sc_mcu7t5v0__dffrnq_1
X_1818_ _1932_/Q _1933_/Q _1934_/Q _1935_/Q _1919_/Q _1822_/A1 VDD VDD VSS VSS gf180mcu_fd_sc_mcu7t5v0__aoi221_1
X_1749_ _1747_/Z _1749_/A2 _2068_/D VDD VDD VSS VSS gf180mcu_fd_sc_mcu7t5v0__nor2_1
XFILLER_89_136 VDD VDD VSS VSS gf180mcu_fd_sc_mcu7t5v0__fillcap_4
XTAP_TAPCELL_ROW_90_1071 VDD VSS gf180mcu_fd_sc_mcu7t5v0__filltie
XFILLER_58_589 VDD VDD VSS VSS gf180mcu_fd_sc_mcu7t5v0__fillcap_4
XFILLER_45_206 VDD VDD VSS VSS gf180mcu_fd_sc_mcu7t5v0__fillcap_4
XTAP_TAPCELL_ROW_56_746 VDD VSS gf180mcu_fd_sc_mcu7t5v0__filltie
XFILLER_81_570 VDD VDD VSS VSS gf180mcu_fd_sc_mcu7t5v0__fillcap_4
XFILLER_42_43 VDD VDD VSS VSS gf180mcu_fd_sc_mcu7t5v0__fill_1
XTAP_TAPCELL_ROW_11_315 VDD VSS gf180mcu_fd_sc_mcu7t5v0__filltie
XPHY_EDGE_ROW_79_Left_178 VDD VSS gf180mcu_fd_sc_mcu7t5v0__endcap
XFILLER_89_692 VDD VDD VSS VSS gf180mcu_fd_sc_mcu7t5v0__fill_2
XFILLER_49_556 VDD VDD VSS VSS gf180mcu_fd_sc_mcu7t5v0__fillcap_4
XFILLER_76_353 VDD VDD VSS VSS gf180mcu_fd_sc_mcu7t5v0__fill_1
XFILLER_36_239 VDD VDD VSS VSS gf180mcu_fd_sc_mcu7t5v0__fillcap_4
XFILLER_17_475 VDD VDD VSS VSS gf180mcu_fd_sc_mcu7t5v0__fillcap_8
XTAP_TAPCELL_ROW_27_470 VDD VSS gf180mcu_fd_sc_mcu7t5v0__filltie
XFILLER_83_72 VDD VDD VSS VSS gf180mcu_fd_sc_mcu7t5v0__fillcap_16
XPHY_EDGE_ROW_88_Left_187 VDD VSS gf180mcu_fd_sc_mcu7t5v0__endcap
X_0982_ _0982_/A1 _1583_/A4 _1328_/B _1319_/B _1673_/A4 VDD VDD VSS VSS gf180mcu_fd_sc_mcu7t5v0__nor4_1
XFILLER_13_692 VDD VDD VSS VSS gf180mcu_fd_sc_mcu7t5v0__fill_2
X_1603_ _1977_/Q input28/Z _1603_/S _1977_/D VDD VDD VSS VSS gf180mcu_fd_sc_mcu7t5v0__mux2_2
X_1534_ _1534_/A1 _2119_/Q _1932_/Q _1935_/Q _1538_/A3 VDD VDD VSS VSS gf180mcu_fd_sc_mcu7t5v0__nand4_1
XPHY_EDGE_ROW_97_Left_196 VDD VSS gf180mcu_fd_sc_mcu7t5v0__endcap
X_1465_ _1464_/Z _1899_/Q _1473_/S _1899_/D VDD VDD VSS VSS gf180mcu_fd_sc_mcu7t5v0__mux2_2
XFILLER_87_629 VDD VDD VSS VSS gf180mcu_fd_sc_mcu7t5v0__fill_1
X_1396_ input41/Z _1396_/A2 _1396_/B1 input57/Z _1397_/A2 VDD VDD VSS VSS gf180mcu_fd_sc_mcu7t5v0__aoi22_1
XFILLER_27_206 VDD VDD VSS VSS gf180mcu_fd_sc_mcu7t5v0__fillcap_4
XFILLER_27_228 VDD VDD VSS VSS gf180mcu_fd_sc_mcu7t5v0__fillcap_4
XFILLER_67_386 VDD VDD VSS VSS gf180mcu_fd_sc_mcu7t5v0__fillcap_4
X_2017_ _2017_/D _2031_/RN _2031_/CLK _2017_/Q VDD VDD VSS VSS gf180mcu_fd_sc_mcu7t5v0__dffrnq_1
XFILLER_70_518 VDD VDD VSS VSS gf180mcu_fd_sc_mcu7t5v0__fillcap_4
XTAP_TAPCELL_ROW_53_716 VDD VSS gf180mcu_fd_sc_mcu7t5v0__filltie
XFILLER_63_570 VDD VDD VSS VSS gf180mcu_fd_sc_mcu7t5v0__fillcap_4
XFILLER_11_629 VDD VDD VSS VSS gf180mcu_fd_sc_mcu7t5v0__fill_1
XFILLER_23_478 VDD VDD VSS VSS gf180mcu_fd_sc_mcu7t5v0__fill_2
XFILLER_50_275 VDD VDD VSS VSS gf180mcu_fd_sc_mcu7t5v0__fillcap_16
XTAP_TAPCELL_ROW_61_793 VDD VSS gf180mcu_fd_sc_mcu7t5v0__filltie
XFILLER_77_139 VDD VDD VSS VSS gf180mcu_fd_sc_mcu7t5v0__fill_1
XTAP_TAPCELL_ROW_69_871 VDD VSS gf180mcu_fd_sc_mcu7t5v0__filltie
XFILLER_26_294 VDD VDD VSS VSS gf180mcu_fd_sc_mcu7t5v0__fillcap_16
XTAP_TAPCELL_ROW_24_440 VDD VSS gf180mcu_fd_sc_mcu7t5v0__filltie
XFILLER_6_633 VDD VDD VSS VSS gf180mcu_fd_sc_mcu7t5v0__fillcap_32
Xclkbuf_5_13__f_periph_clk_i clkbuf_4_6_0_periph_clk_i/Z _2063_/CLK VDD VDD VSS VSS
+ gf180mcu_fd_sc_mcu7t5v0__clkbuf_16
X_1250_ _1250_/A1 _2105_/Q _2159_/D VDD VDD VSS VSS gf180mcu_fd_sc_mcu7t5v0__nand2_1
X_1181_ _1191_/A1 _1961_/Q _1333_/A1 _1604_/A3 _1181_/Z VDD VDD VSS VSS gf180mcu_fd_sc_mcu7t5v0__and4_1
XFILLER_37_559 VDD VDD VSS VSS gf180mcu_fd_sc_mcu7t5v0__fill_1
XFILLER_91_142 VDD VDD VSS VSS gf180mcu_fd_sc_mcu7t5v0__fillcap_64
XFILLER_64_389 VDD VDD VSS VSS gf180mcu_fd_sc_mcu7t5v0__fill_1
XFILLER_32_242 VDD VDD VSS VSS gf180mcu_fd_sc_mcu7t5v0__fill_2
X_0965_ _0965_/A1 _2040_/Q _2193_/D _0965_/ZN VDD VDD VSS VSS gf180mcu_fd_sc_mcu7t5v0__nor3_1
XTAP_TAPCELL_ROW_30_498 VDD VSS gf180mcu_fd_sc_mcu7t5v0__filltie
Xoutput201 _2011_/Q wire359/I VDD VDD VSS VSS gf180mcu_fd_sc_mcu7t5v0__buf_1
Xoutput212 _1310_/Z wire288/I VDD VDD VSS VSS gf180mcu_fd_sc_mcu7t5v0__buf_1
X_1517_ _1523_/A1 _1517_/A2 _1517_/B _1922_/D VDD VDD VSS VSS gf180mcu_fd_sc_mcu7t5v0__oai21_1
X_1448_ _2042_/Q _2040_/Q _1448_/A3 _1449_/C VDD VDD VSS VSS gf180mcu_fd_sc_mcu7t5v0__nor3_1
XFILLER_67_150 VDD VDD VSS VSS gf180mcu_fd_sc_mcu7t5v0__fill_2
X_1379_ _1379_/A1 _1379_/A2 _1379_/A3 _1379_/ZN VDD VDD VSS VSS gf180mcu_fd_sc_mcu7t5v0__nand3_1
XFILLER_95_492 VDD VDD VSS VSS gf180mcu_fd_sc_mcu7t5v0__fillcap_8
XFILLER_83_632 VDD VDD VSS VSS gf180mcu_fd_sc_mcu7t5v0__fillcap_32
XTAP_TAPCELL_ROW_66_841 VDD VSS gf180mcu_fd_sc_mcu7t5v0__filltie
XFILLER_15_209 VDD VDD VSS VSS gf180mcu_fd_sc_mcu7t5v0__fill_1
XTAP_TAPCELL_ROW_38_576 VDD VSS gf180mcu_fd_sc_mcu7t5v0__filltie
Xwire306 wire306/I cfg_data_o[19] VDD VDD VSS VSS gf180mcu_fd_sc_mcu7t5v0__clkbuf_3
XTAP_TAPCELL_ROW_21_410 VDD VSS gf180mcu_fd_sc_mcu7t5v0__filltie
XFILLER_51_595 VDD VDD VSS VSS gf180mcu_fd_sc_mcu7t5v0__fill_1
Xfanout450 fanout458/Z _2190_/RN VDD VDD VSS VSS gf180mcu_fd_sc_mcu7t5v0__dlyb_1
Xfanout472 _2172_/RN _2161_/RN VDD VDD VSS VSS gf180mcu_fd_sc_mcu7t5v0__buf_1
XFILLER_93_407 VDD VDD VSS VSS gf180mcu_fd_sc_mcu7t5v0__fillcap_4
XFILLER_48_53 VDD VDD VSS VSS gf180mcu_fd_sc_mcu7t5v0__fillcap_8
XFILLER_19_559 VDD VDD VSS VSS gf180mcu_fd_sc_mcu7t5v0__fill_1
XFILLER_73_153 VDD VDD VSS VSS gf180mcu_fd_sc_mcu7t5v0__fill_2
XFILLER_73_142 VDD VDD VSS VSS gf180mcu_fd_sc_mcu7t5v0__fillcap_4
XFILLER_61_337 VDD VDD VSS VSS gf180mcu_fd_sc_mcu7t5v0__fillcap_8
XTAP_TAPCELL_ROW_72_899 VDD VSS gf180mcu_fd_sc_mcu7t5v0__filltie
XFILLER_2_691 VDD VDD VSS VSS gf180mcu_fd_sc_mcu7t5v0__fill_2
X_1302_ _1156_/B _1302_/A2 _1304_/A2 VDD VDD VSS VSS gf180mcu_fd_sc_mcu7t5v0__nand2_1
X_1233_ _1240_/A1 _1240_/A2 _1240_/A3 _1243_/A4 VDD VDD VSS VSS gf180mcu_fd_sc_mcu7t5v0__nor3_1
XFILLER_49_150 VDD VDD VSS VSS gf180mcu_fd_sc_mcu7t5v0__fillcap_4
XFILLER_77_492 VDD VDD VSS VSS gf180mcu_fd_sc_mcu7t5v0__fillcap_32
XFILLER_65_632 VDD VDD VSS VSS gf180mcu_fd_sc_mcu7t5v0__fillcap_32
X_1164_ _1164_/I _1251_/B VDD VDD VSS VSS gf180mcu_fd_sc_mcu7t5v0__clkinv_1
XFILLER_64_131 VDD VDD VSS VSS gf180mcu_fd_sc_mcu7t5v0__fill_2
X_1095_ _2095_/Q _2171_/Q _1095_/Z VDD VDD VSS VSS gf180mcu_fd_sc_mcu7t5v0__or2_1
XTAP_TAPCELL_ROW_63_811 VDD VSS gf180mcu_fd_sc_mcu7t5v0__filltie
XTAP_TAPCELL_ROW_35_546 VDD VSS gf180mcu_fd_sc_mcu7t5v0__filltie
XFILLER_33_562 VDD VDD VSS VSS gf180mcu_fd_sc_mcu7t5v0__fillcap_32
XFILLER_60_381 VDD VDD VSS VSS gf180mcu_fd_sc_mcu7t5v0__fillcap_4
X_1997_ _1997_/D _2031_/RN _2000_/CLK _1997_/Q VDD VDD VSS VSS gf180mcu_fd_sc_mcu7t5v0__dffrnq_1
X_0948_ _2182_/Q _1167_/B1 VDD VDD VSS VSS gf180mcu_fd_sc_mcu7t5v0__clkinv_1
XFILLER_87_212 VDD VDD VSS VSS gf180mcu_fd_sc_mcu7t5v0__fillcap_64
XFILLER_18_34 VDD VDD VSS VSS gf180mcu_fd_sc_mcu7t5v0__fill_1
XTAP_TAPCELL_ROW_87_1043 VDD VSS gf180mcu_fd_sc_mcu7t5v0__filltie
XFILLER_55_142 VDD VDD VSS VSS gf180mcu_fd_sc_mcu7t5v0__fillcap_4
XFILLER_55_131 VDD VDD VSS VSS gf180mcu_fd_sc_mcu7t5v0__fillcap_8
XFILLER_83_462 VDD VDD VSS VSS gf180mcu_fd_sc_mcu7t5v0__fill_1
XFILLER_71_602 VDD VDD VSS VSS gf180mcu_fd_sc_mcu7t5v0__fill_2
XFILLER_11_212 VDD VDD VSS VSS gf180mcu_fd_sc_mcu7t5v0__fill_2
XFILLER_7_216 VDD VDD VSS VSS gf180mcu_fd_sc_mcu7t5v0__fill_1
XTAP_TAPCELL_ROW_98_1150 VDD VSS gf180mcu_fd_sc_mcu7t5v0__filltie
XFILLER_3_422 VDD VDD VSS VSS gf180mcu_fd_sc_mcu7t5v0__fillcap_4
XTAP_TAPCELL_ROW_6_271 VDD VSS gf180mcu_fd_sc_mcu7t5v0__filltie
XTAP_TAPCELL_ROW_77_947 VDD VSS gf180mcu_fd_sc_mcu7t5v0__filltie
XFILLER_59_492 VDD VDD VSS VSS gf180mcu_fd_sc_mcu7t5v0__fillcap_32
XFILLER_74_440 VDD VDD VSS VSS gf180mcu_fd_sc_mcu7t5v0__fillcap_8
XFILLER_46_197 VDD VDD VSS VSS gf180mcu_fd_sc_mcu7t5v0__fill_2
XFILLER_15_540 VDD VDD VSS VSS gf180mcu_fd_sc_mcu7t5v0__fillcap_8
XFILLER_15_562 VDD VDD VSS VSS gf180mcu_fd_sc_mcu7t5v0__fill_1
X_1920_ _1920_/D _1927_/RN _2037_/CLK _1920_/Q VDD VDD VSS VSS gf180mcu_fd_sc_mcu7t5v0__dffrnq_1
XTAP_TAPCELL_ROW_32_516 VDD VSS gf180mcu_fd_sc_mcu7t5v0__filltie
XFILLER_91_72 VDD VDD VSS VSS gf180mcu_fd_sc_mcu7t5v0__fillcap_64
X_1851_ _1973_/Q _2098_/Q _1853_/S _2098_/D VDD VDD VSS VSS gf180mcu_fd_sc_mcu7t5v0__mux2_2
XFILLER_30_576 VDD VDD VSS VSS gf180mcu_fd_sc_mcu7t5v0__fillcap_16
X_1782_ _1799_/C _1782_/A2 _1782_/A3 _1784_/A2 VDD VDD VSS VSS gf180mcu_fd_sc_mcu7t5v0__nand3_1
XTAP_TAPCELL_ROW_40_593 VDD VSS gf180mcu_fd_sc_mcu7t5v0__filltie
XFILLER_69_212 VDD VDD VSS VSS gf180mcu_fd_sc_mcu7t5v0__fillcap_32
XFILLER_97_554 VDD VDD VSS VSS gf180mcu_fd_sc_mcu7t5v0__fillcap_4
X_1216_ _2136_/Q _1211_/Z _2137_/Q _1220_/A2 VDD VDD VSS VSS gf180mcu_fd_sc_mcu7t5v0__aoi21_1
X_1147_ _1147_/A1 _1147_/A2 _1147_/A3 _1147_/A4 _1150_/A2 VDD VDD VSS VSS gf180mcu_fd_sc_mcu7t5v0__nand4_1
XTAP_TAPCELL_ROW_48_671 VDD VSS gf180mcu_fd_sc_mcu7t5v0__filltie
XFILLER_38_676 VDD VDD VSS VSS gf180mcu_fd_sc_mcu7t5v0__fill_2
X_1078_ _2098_/Q _1296_/A2 _1156_/B _2100_/Q _1080_/A3 VDD VDD VSS VSS gf180mcu_fd_sc_mcu7t5v0__aoi22_1
XFILLER_80_454 VDD VDD VSS VSS gf180mcu_fd_sc_mcu7t5v0__fill_1
XFILLER_53_679 VDD VDD VSS VSS gf180mcu_fd_sc_mcu7t5v0__fillcap_8
XFILLER_80_487 VDD VDD VSS VSS gf180mcu_fd_sc_mcu7t5v0__fillcap_8
XFILLER_52_189 VDD VDD VSS VSS gf180mcu_fd_sc_mcu7t5v0__fillcap_16
XFILLER_33_392 VDD VDD VSS VSS gf180mcu_fd_sc_mcu7t5v0__fill_2
Xclkbuf_5_13__f_sys_clk_i clkbuf_4_6_0_sys_clk_i/Z _2189_/CLK VDD VDD VSS VSS gf180mcu_fd_sc_mcu7t5v0__clkbuf_16
XFILLER_29_621 VDD VDD VSS VSS gf180mcu_fd_sc_mcu7t5v0__fill_1
XFILLER_48_429 VDD VDD VSS VSS gf180mcu_fd_sc_mcu7t5v0__fillcap_16
XFILLER_29_88 VDD VDD VSS VSS gf180mcu_fd_sc_mcu7t5v0__fillcap_4
XTAP_TAPCELL_ROW_3_241 VDD VSS gf180mcu_fd_sc_mcu7t5v0__filltie
XTAP_TAPCELL_ROW_74_917 VDD VSS gf180mcu_fd_sc_mcu7t5v0__filltie
XFILLER_56_462 VDD VDD VSS VSS gf180mcu_fd_sc_mcu7t5v0__fill_2
XFILLER_16_348 VDD VDD VSS VSS gf180mcu_fd_sc_mcu7t5v0__fillcap_16
XTAP_TAPCELL_ROW_82_994 VDD VSS gf180mcu_fd_sc_mcu7t5v0__filltie
XFILLER_6_37 VDD VDD VSS VSS gf180mcu_fd_sc_mcu7t5v0__fillcap_32
XPHY_EDGE_ROW_60_Left_159 VDD VSS gf180mcu_fd_sc_mcu7t5v0__endcap
XFILLER_79_554 VDD VDD VSS VSS gf180mcu_fd_sc_mcu7t5v0__fillcap_4
XFILLER_79_598 VDD VDD VSS VSS gf180mcu_fd_sc_mcu7t5v0__fillcap_8
X_2050_ _2050_/D _2188_/RN clkload3/I _2050_/Q VDD VDD VSS VSS gf180mcu_fd_sc_mcu7t5v0__dffrnq_1
XFILLER_19_142 VDD VDD VSS VSS gf180mcu_fd_sc_mcu7t5v0__fillcap_4
X_1001_ _2124_/D _2125_/D _1501_/A2 VDD VDD VSS VSS gf180mcu_fd_sc_mcu7t5v0__nand2_1
XTAP_TAPCELL_ROW_45_641 VDD VSS gf180mcu_fd_sc_mcu7t5v0__filltie
XFILLER_62_465 VDD VDD VSS VSS gf180mcu_fd_sc_mcu7t5v0__fillcap_8
XTAP_TAPCELL_ROW_17_376 VDD VSS gf180mcu_fd_sc_mcu7t5v0__filltie
XFILLER_15_392 VDD VDD VSS VSS gf180mcu_fd_sc_mcu7t5v0__fillcap_4
X_1903_ _1903_/D _1919_/RN _1949_/CLK _1903_/Q VDD VDD VSS VSS gf180mcu_fd_sc_mcu7t5v0__dffrnq_1
XFILLER_89_2 VDD VDD VSS VSS gf180mcu_fd_sc_mcu7t5v0__fillcap_64
XFILLER_30_384 VDD VDD VSS VSS gf180mcu_fd_sc_mcu7t5v0__fill_1
X_1834_ _2082_/Q _1834_/A2 _1834_/B _2082_/D VDD VDD VSS VSS gf180mcu_fd_sc_mcu7t5v0__oai21_1
X_1765_ _1813_/A1 _1789_/A2 _1912_/Q _1766_/A3 VDD VDD VSS VSS gf180mcu_fd_sc_mcu7t5v0__nand3_1
Xhold514 _2193_/Q _2192_/D VDD VDD VSS VSS gf180mcu_fd_sc_mcu7t5v0__dlyc_1
Xhold525 _2110_/Q _2112_/D VDD VDD VSS VSS gf180mcu_fd_sc_mcu7t5v0__dlyc_1
XFILLER_7_591 VDD VDD VSS VSS gf180mcu_fd_sc_mcu7t5v0__fill_2
X_1696_ _1696_/A1 _1696_/A2 _1696_/A3 _2066_/Q _1728_/A1 VDD VDD VSS VSS gf180mcu_fd_sc_mcu7t5v0__nand4_1
Xmax_cap277 _1526_/A1 _1524_/A1 VDD VDD VSS VSS gf180mcu_fd_sc_mcu7t5v0__buf_1
Xmax_cap255 _1412_/S _1414_/S VDD VDD VSS VSS gf180mcu_fd_sc_mcu7t5v0__buf_2
XFILLER_97_340 VDD VDD VSS VSS gf180mcu_fd_sc_mcu7t5v0__fillcap_4
Xload_slew461 _1908_/RN _1951_/RN VDD VDD VSS VSS gf180mcu_fd_sc_mcu7t5v0__buf_2
XFILLER_26_613 VDD VDD VSS VSS gf180mcu_fd_sc_mcu7t5v0__fillcap_4
XTAP_TAPCELL_ROW_0_211 VDD VSS gf180mcu_fd_sc_mcu7t5v0__filltie
XTAP_TAPCELL_ROW_0_200 VDD VSS gf180mcu_fd_sc_mcu7t5v0__filltie
X_2179_ _2179_/D _2194_/RN _2189_/CLK _2179_/Q VDD VDD VSS VSS gf180mcu_fd_sc_mcu7t5v0__dffrnq_1
XTAP_TAPCELL_ROW_84_1013 VDD VSS gf180mcu_fd_sc_mcu7t5v0__filltie
XFILLER_53_410 VDD VDD VSS VSS gf180mcu_fd_sc_mcu7t5v0__fill_1
XFILLER_53_454 VDD VDD VSS VSS gf180mcu_fd_sc_mcu7t5v0__fillcap_16
XFILLER_21_384 VDD VDD VSS VSS gf180mcu_fd_sc_mcu7t5v0__fill_2
XTAP_TAPCELL_ROW_51_699 VDD VSS gf180mcu_fd_sc_mcu7t5v0__filltie
XFILLER_31_89 VDD VDD VSS VSS gf180mcu_fd_sc_mcu7t5v0__fillcap_8
Xinput101 data_tx_gnt_i _1550_/A2 VDD VDD VSS VSS gf180mcu_fd_sc_mcu7t5v0__dlyb_1
Xinput112 uart_rx_i _1248_/A2 VDD VDD VSS VSS gf180mcu_fd_sc_mcu7t5v0__dlyb_1
XFILLER_88_384 VDD VDD VSS VSS gf180mcu_fd_sc_mcu7t5v0__fill_1
XFILLER_76_524 VDD VDD VSS VSS gf180mcu_fd_sc_mcu7t5v0__fill_1
XFILLER_29_440 VDD VDD VSS VSS gf180mcu_fd_sc_mcu7t5v0__fill_1
XFILLER_56_20 VDD VDD VSS VSS gf180mcu_fd_sc_mcu7t5v0__fill_1
XTAP_TAPCELL_ROW_59_777 VDD VSS gf180mcu_fd_sc_mcu7t5v0__filltie
XFILLER_16_101 VDD VDD VSS VSS gf180mcu_fd_sc_mcu7t5v0__fillcap_4
XTAP_TAPCELL_ROW_42_611 VDD VSS gf180mcu_fd_sc_mcu7t5v0__filltie
XFILLER_31_137 VDD VDD VSS VSS gf180mcu_fd_sc_mcu7t5v0__fill_2
XTAP_TAPCELL_ROW_14_346 VDD VSS gf180mcu_fd_sc_mcu7t5v0__filltie
XFILLER_12_384 VDD VDD VSS VSS gf180mcu_fd_sc_mcu7t5v0__fill_1
XFILLER_12_395 VDD VDD VSS VSS gf180mcu_fd_sc_mcu7t5v0__fillcap_4
X_1550_ _1550_/A1 _1550_/A2 _1550_/B _1556_/B2 VDD VDD VSS VSS gf180mcu_fd_sc_mcu7t5v0__aoi21_1
Xudma_uart_top_484 data_rx_o[8] VDD VDD VSS VSS gf180mcu_fd_sc_mcu7t5v0__tiel
Xudma_uart_top_495 data_rx_o[19] VDD VDD VSS VSS gf180mcu_fd_sc_mcu7t5v0__tiel
XFILLER_98_104 VDD VDD VSS VSS gf180mcu_fd_sc_mcu7t5v0__fillcap_32
X_1481_ _1511_/B _1460_/Z _1511_/C _1515_/A2 VDD VDD VSS VSS gf180mcu_fd_sc_mcu7t5v0__nand3_1
XFILLER_4_594 VDD VDD VSS VSS gf180mcu_fd_sc_mcu7t5v0__fill_1
XFILLER_67_524 VDD VDD VSS VSS gf180mcu_fd_sc_mcu7t5v0__fill_1
X_2102_ _2102_/D _2187_/RN _2187_/CLK _2102_/Q VDD VDD VSS VSS gf180mcu_fd_sc_mcu7t5v0__dffrnq_1
XFILLER_67_557 VDD VDD VSS VSS gf180mcu_fd_sc_mcu7t5v0__fill_2
XFILLER_94_387 VDD VDD VSS VSS gf180mcu_fd_sc_mcu7t5v0__fillcap_4
XFILLER_82_527 VDD VDD VSS VSS gf180mcu_fd_sc_mcu7t5v0__fillcap_4
X_2033_ _2033_/D _2033_/RN _2034_/CLK _2033_/Q VDD VDD VSS VSS gf180mcu_fd_sc_mcu7t5v0__dffrnq_1
XFILLER_90_560 VDD VDD VSS VSS gf180mcu_fd_sc_mcu7t5v0__fill_1
XFILLER_50_457 VDD VDD VSS VSS gf180mcu_fd_sc_mcu7t5v0__fill_1
X_1817_ _1817_/A1 _1817_/A2 _1817_/B _1817_/C _2077_/D VDD VDD VSS VSS gf180mcu_fd_sc_mcu7t5v0__oai211_1
XFILLER_7_80 VDD VDD VSS VSS gf180mcu_fd_sc_mcu7t5v0__fill_2
X_1748_ _2068_/Q _1757_/A1 _2108_/Q _1749_/A2 VDD VDD VSS VSS gf180mcu_fd_sc_mcu7t5v0__oai21_1
X_1679_ _2045_/Q _1307_/Z _1684_/S _2045_/D VDD VDD VSS VSS gf180mcu_fd_sc_mcu7t5v0__mux2_2
XTAP_TAPCELL_ROW_90_1072 VDD VSS gf180mcu_fd_sc_mcu7t5v0__filltie
XFILLER_98_682 VDD VDD VSS VSS gf180mcu_fd_sc_mcu7t5v0__fillcap_8
XFILLER_85_332 VDD VDD VSS VSS gf180mcu_fd_sc_mcu7t5v0__fill_2
XFILLER_58_535 VDD VDD VSS VSS gf180mcu_fd_sc_mcu7t5v0__fillcap_4
XFILLER_73_516 VDD VDD VSS VSS gf180mcu_fd_sc_mcu7t5v0__fill_1
XFILLER_26_421 VDD VDD VSS VSS gf180mcu_fd_sc_mcu7t5v0__fillcap_4
XTAP_TAPCELL_ROW_56_747 VDD VSS gf180mcu_fd_sc_mcu7t5v0__filltie
XFILLER_26_34 VDD VDD VSS VSS gf180mcu_fd_sc_mcu7t5v0__fill_1
XFILLER_26_454 VDD VDD VSS VSS gf180mcu_fd_sc_mcu7t5v0__fill_1
XFILLER_13_104 VDD VDD VSS VSS gf180mcu_fd_sc_mcu7t5v0__fillcap_16
XFILLER_53_273 VDD VDD VSS VSS gf180mcu_fd_sc_mcu7t5v0__fillcap_4
XFILLER_42_33 VDD VDD VSS VSS gf180mcu_fd_sc_mcu7t5v0__fill_2
XFILLER_22_682 VDD VDD VSS VSS gf180mcu_fd_sc_mcu7t5v0__fill_1
XTAP_TAPCELL_ROW_11_316 VDD VSS gf180mcu_fd_sc_mcu7t5v0__filltie
Xclkbuf_5_21__f_periph_clk_i clkbuf_4_10_0_periph_clk_i/Z _2134_/CLK VDD VDD VSS VSS
+ gf180mcu_fd_sc_mcu7t5v0__clkbuf_16
XFILLER_76_387 VDD VDD VSS VSS gf180mcu_fd_sc_mcu7t5v0__fillcap_16
XFILLER_91_346 VDD VDD VSS VSS gf180mcu_fd_sc_mcu7t5v0__fillcap_4
XFILLER_17_487 VDD VDD VSS VSS gf180mcu_fd_sc_mcu7t5v0__fill_2
XTAP_TAPCELL_ROW_27_471 VDD VSS gf180mcu_fd_sc_mcu7t5v0__filltie
X_0981_ input1/Z _0983_/A3 _1648_/A2 VDD VDD VSS VSS gf180mcu_fd_sc_mcu7t5v0__nand2_1
XFILLER_9_620 VDD VDD VSS VSS gf180mcu_fd_sc_mcu7t5v0__fillcap_8
XFILLER_9_664 VDD VDD VSS VSS gf180mcu_fd_sc_mcu7t5v0__fillcap_16
X_1602_ _1976_/Q input17/Z _1603_/S _1976_/D VDD VDD VSS VSS gf180mcu_fd_sc_mcu7t5v0__mux2_2
XFILLER_66_4 VDD VDD VSS VSS gf180mcu_fd_sc_mcu7t5v0__fill_1
X_1533_ _1535_/A3 _1934_/Q _2118_/Q _1935_/Q _1538_/A2 VDD VDD VSS VSS gf180mcu_fd_sc_mcu7t5v0__nand4_1
X_1464_ _1943_/Q _1951_/Q _1472_/S _1464_/Z VDD VDD VSS VSS gf180mcu_fd_sc_mcu7t5v0__mux2_2
Xclkbuf_5_1__f_sys_clk_i clkbuf_4_0_0_sys_clk_i/Z _2024_/CLK VDD VDD VSS VSS gf180mcu_fd_sc_mcu7t5v0__clkbuf_16
XFILLER_4_380 VDD VDD VSS VSS gf180mcu_fd_sc_mcu7t5v0__fillcap_4
XFILLER_86_107 VDD VDD VSS VSS gf180mcu_fd_sc_mcu7t5v0__fillcap_64
X_1395_ input71/Z _1395_/A2 _1395_/B1 input87/Z _1397_/A1 VDD VDD VSS VSS gf180mcu_fd_sc_mcu7t5v0__aoi22_1
XFILLER_67_310 VDD VDD VSS VSS gf180mcu_fd_sc_mcu7t5v0__fill_2
X_2016_ _2016_/D _2028_/RN _2024_/CLK _2016_/Q VDD VDD VSS VSS gf180mcu_fd_sc_mcu7t5v0__dffrnq_1
XTAP_TAPCELL_ROW_53_717 VDD VSS gf180mcu_fd_sc_mcu7t5v0__filltie
XFILLER_10_107 VDD VDD VSS VSS gf180mcu_fd_sc_mcu7t5v0__fill_1
XTAP_TAPCELL_ROW_61_794 VDD VSS gf180mcu_fd_sc_mcu7t5v0__filltie
XFILLER_2_317 VDD VDD VSS VSS gf180mcu_fd_sc_mcu7t5v0__fill_2
XTAP_TAPCELL_ROW_69_872 VDD VSS gf180mcu_fd_sc_mcu7t5v0__filltie
XFILLER_46_505 VDD VDD VSS VSS gf180mcu_fd_sc_mcu7t5v0__fillcap_16
XFILLER_58_387 VDD VDD VSS VSS gf180mcu_fd_sc_mcu7t5v0__fillcap_32
XFILLER_46_527 VDD VDD VSS VSS gf180mcu_fd_sc_mcu7t5v0__fillcap_8
XFILLER_73_346 VDD VDD VSS VSS gf180mcu_fd_sc_mcu7t5v0__fillcap_4
XFILLER_14_446 VDD VDD VSS VSS gf180mcu_fd_sc_mcu7t5v0__fillcap_8
XFILLER_14_457 VDD VDD VSS VSS gf180mcu_fd_sc_mcu7t5v0__fillcap_16
XTAP_TAPCELL_ROW_24_441 VDD VSS gf180mcu_fd_sc_mcu7t5v0__filltie
XFILLER_41_298 VDD VDD VSS VSS gf180mcu_fd_sc_mcu7t5v0__fillcap_8
XFILLER_6_667 VDD VDD VSS VSS gf180mcu_fd_sc_mcu7t5v0__fillcap_8
XFILLER_78_51 VDD VDD VSS VSS gf180mcu_fd_sc_mcu7t5v0__fill_1
XFILLER_68_107 VDD VDD VSS VSS gf180mcu_fd_sc_mcu7t5v0__fillcap_16
XFILLER_49_310 VDD VDD VSS VSS gf180mcu_fd_sc_mcu7t5v0__fill_1
X_1180_ _1191_/A1 _1960_/Q _1191_/A3 _1191_/A4 _1180_/Z VDD VDD VSS VSS gf180mcu_fd_sc_mcu7t5v0__and4_1
XFILLER_49_343 VDD VDD VSS VSS gf180mcu_fd_sc_mcu7t5v0__fill_1
XFILLER_49_376 VDD VDD VSS VSS gf180mcu_fd_sc_mcu7t5v0__fill_2
XFILLER_64_379 VDD VDD VSS VSS gf180mcu_fd_sc_mcu7t5v0__fillcap_4
XFILLER_20_438 VDD VDD VSS VSS gf180mcu_fd_sc_mcu7t5v0__fillcap_4
X_0964_ _2191_/Q _2042_/Q _0965_/A1 VDD VDD VSS VSS gf180mcu_fd_sc_mcu7t5v0__nand2_1
XTAP_TAPCELL_ROW_30_499 VDD VSS gf180mcu_fd_sc_mcu7t5v0__filltie
Xclkbuf_5_18__f_sys_clk_i clkbuf_4_9_0_sys_clk_i/Z _2128_/CLK VDD VDD VSS VSS gf180mcu_fd_sc_mcu7t5v0__clkbuf_16
Xoutput213 _1311_/Z wire287/I VDD VDD VSS VSS gf180mcu_fd_sc_mcu7t5v0__buf_1
Xoutput202 _2012_/Q wire358/I VDD VDD VSS VSS gf180mcu_fd_sc_mcu7t5v0__buf_1
X_1516_ _1524_/A1 _1922_/Q _1517_/B VDD VDD VSS VSS gf180mcu_fd_sc_mcu7t5v0__nand2_1
XFILLER_87_416 VDD VDD VSS VSS gf180mcu_fd_sc_mcu7t5v0__fillcap_4
X_1447_ _1685_/A1 _1446_/Z _1686_/A2 VDD VDD VSS VSS gf180mcu_fd_sc_mcu7t5v0__nand2_1
XFILLER_4_81 VDD VDD VSS VSS gf180mcu_fd_sc_mcu7t5v0__fillcap_4
X_1378_ _1378_/A1 _1329_/Z _1325_/Z _2048_/Q _1393_/B1 input62/Z _1379_/A3 VDD VDD
+ VSS VSS gf180mcu_fd_sc_mcu7t5v0__aoi222_1
XFILLER_28_549 VDD VDD VSS VSS gf180mcu_fd_sc_mcu7t5v0__fill_1
XFILLER_67_162 VDD VDD VSS VSS gf180mcu_fd_sc_mcu7t5v0__fill_1
XTAP_TAPCELL_ROW_66_842 VDD VSS gf180mcu_fd_sc_mcu7t5v0__filltie
XFILLER_43_508 VDD VDD VSS VSS gf180mcu_fd_sc_mcu7t5v0__fillcap_4
XFILLER_36_571 VDD VDD VSS VSS gf180mcu_fd_sc_mcu7t5v0__fillcap_8
XTAP_TAPCELL_ROW_38_577 VDD VSS gf180mcu_fd_sc_mcu7t5v0__filltie
XFILLER_83_688 VDD VDD VSS VSS gf180mcu_fd_sc_mcu7t5v0__fillcap_4
XFILLER_55_379 VDD VDD VSS VSS gf180mcu_fd_sc_mcu7t5v0__fill_2
XFILLER_51_541 VDD VDD VSS VSS gf180mcu_fd_sc_mcu7t5v0__fillcap_16
XFILLER_11_405 VDD VDD VSS VSS gf180mcu_fd_sc_mcu7t5v0__fill_1
XFILLER_11_438 VDD VDD VSS VSS gf180mcu_fd_sc_mcu7t5v0__fillcap_4
XTAP_TAPCELL_ROW_21_411 VDD VSS gf180mcu_fd_sc_mcu7t5v0__filltie
Xwire307 wire307/I cfg_data_o[18] VDD VDD VSS VSS gf180mcu_fd_sc_mcu7t5v0__clkbuf_3
XFILLER_7_409 VDD VDD VSS VSS gf180mcu_fd_sc_mcu7t5v0__fill_2
Xfanout440 _2020_/RN _2117_/RN VDD VDD VSS VSS gf180mcu_fd_sc_mcu7t5v0__dlyb_1
Xfanout451 _0904_/I _2051_/RN VDD VDD VSS VSS gf180mcu_fd_sc_mcu7t5v0__dlyb_1
Xfanout462 _2176_/RN _1927_/RN VDD VDD VSS VSS gf180mcu_fd_sc_mcu7t5v0__dlyb_1
Xfanout473 _2176_/RN _2172_/RN VDD VDD VSS VSS gf180mcu_fd_sc_mcu7t5v0__dlyb_1
XFILLER_93_419 VDD VDD VSS VSS gf180mcu_fd_sc_mcu7t5v0__fill_1
Xclkbuf_5_20__f_sys_clk_i clkbuf_4_10_0_sys_clk_i/Z _1955_/CLK VDD VDD VSS VSS gf180mcu_fd_sc_mcu7t5v0__clkbuf_16
XFILLER_73_121 VDD VDD VSS VSS gf180mcu_fd_sc_mcu7t5v0__fillcap_8
XFILLER_64_31 VDD VDD VSS VSS gf180mcu_fd_sc_mcu7t5v0__fillcap_4
XFILLER_61_349 VDD VDD VSS VSS gf180mcu_fd_sc_mcu7t5v0__fill_1
XFILLER_14_243 VDD VDD VSS VSS gf180mcu_fd_sc_mcu7t5v0__fill_2
XFILLER_80_96 VDD VDD VSS VSS gf180mcu_fd_sc_mcu7t5v0__fill_1
XFILLER_89_72 VDD VDD VSS VSS gf180mcu_fd_sc_mcu7t5v0__fillcap_64
X_1301_ _1304_/A1 _1301_/A2 _1302_/A2 _1304_/A4 _2175_/D VDD VDD VSS VSS gf180mcu_fd_sc_mcu7t5v0__and4_1
X_1232_ _2140_/Q _2141_/Q _1240_/A3 VDD VDD VSS VSS gf180mcu_fd_sc_mcu7t5v0__nand2_1
X_1163_ _2110_/D _1697_/B1 _1163_/B _1163_/C _1164_/I VDD VDD VSS VSS gf180mcu_fd_sc_mcu7t5v0__oai211_1
X_1094_ _2095_/Q _2171_/Q _1096_/B1 VDD VDD VSS VSS gf180mcu_fd_sc_mcu7t5v0__nand2_1
XTAP_TAPCELL_ROW_63_812 VDD VSS gf180mcu_fd_sc_mcu7t5v0__filltie
XFILLER_92_463 VDD VDD VSS VSS gf180mcu_fd_sc_mcu7t5v0__fill_2
XFILLER_65_688 VDD VDD VSS VSS gf180mcu_fd_sc_mcu7t5v0__fillcap_4
XTAP_TAPCELL_ROW_35_547 VDD VSS gf180mcu_fd_sc_mcu7t5v0__filltie
X_1996_ _1996_/D _2025_/RN _2025_/CLK _1996_/Q VDD VDD VSS VSS gf180mcu_fd_sc_mcu7t5v0__dffrnq_1
X_0947_ _2176_/Q _1156_/B VDD VDD VSS VSS gf180mcu_fd_sc_mcu7t5v0__clkinv_1
XFILLER_83_485 VDD VDD VSS VSS gf180mcu_fd_sc_mcu7t5v0__fillcap_4
XFILLER_55_176 VDD VDD VSS VSS gf180mcu_fd_sc_mcu7t5v0__fillcap_32
XFILLER_70_124 VDD VDD VSS VSS gf180mcu_fd_sc_mcu7t5v0__fillcap_8
XFILLER_43_349 VDD VDD VSS VSS gf180mcu_fd_sc_mcu7t5v0__fill_1
XFILLER_43_338 VDD VDD VSS VSS gf180mcu_fd_sc_mcu7t5v0__fill_1
XFILLER_24_541 VDD VDD VSS VSS gf180mcu_fd_sc_mcu7t5v0__fill_1
XFILLER_34_34 VDD VDD VSS VSS gf180mcu_fd_sc_mcu7t5v0__fill_1
XFILLER_34_45 VDD VDD VSS VSS gf180mcu_fd_sc_mcu7t5v0__fillcap_4
XFILLER_51_382 VDD VDD VSS VSS gf180mcu_fd_sc_mcu7t5v0__fillcap_8
XFILLER_51_360 VDD VDD VSS VSS gf180mcu_fd_sc_mcu7t5v0__fill_2
Xclkload0 clkload0/I clkload0/Z VDD VDD VSS VSS gf180mcu_fd_sc_mcu7t5v0__clkbuf_2
XTAP_TAPCELL_ROW_98_1151 VDD VSS gf180mcu_fd_sc_mcu7t5v0__filltie
XTAP_TAPCELL_ROW_98_1140 VDD VSS gf180mcu_fd_sc_mcu7t5v0__filltie
XFILLER_1_2 VDD VDD VSS VSS gf180mcu_fd_sc_mcu7t5v0__fillcap_32
Xfanout270 _1601_/S _1596_/S VDD VDD VSS VSS gf180mcu_fd_sc_mcu7t5v0__dlyb_1
XTAP_TAPCELL_ROW_77_948 VDD VSS gf180mcu_fd_sc_mcu7t5v0__filltie
XTAP_TAPCELL_ROW_6_272 VDD VSS gf180mcu_fd_sc_mcu7t5v0__filltie
XFILLER_74_452 VDD VDD VSS VSS gf180mcu_fd_sc_mcu7t5v0__fill_2
XFILLER_15_552 VDD VDD VSS VSS gf180mcu_fd_sc_mcu7t5v0__fill_2
XFILLER_61_146 VDD VDD VSS VSS gf180mcu_fd_sc_mcu7t5v0__fill_1
XTAP_TAPCELL_ROW_32_517 VDD VSS gf180mcu_fd_sc_mcu7t5v0__filltie
XFILLER_70_691 VDD VDD VSS VSS gf180mcu_fd_sc_mcu7t5v0__fill_2
XFILLER_42_382 VDD VDD VSS VSS gf180mcu_fd_sc_mcu7t5v0__fill_2
X_1850_ _1972_/Q _2097_/Q _1853_/S _2097_/D VDD VDD VSS VSS gf180mcu_fd_sc_mcu7t5v0__mux2_2
X_1781_ _1813_/A1 _1789_/A2 _1914_/Q _1782_/A3 VDD VDD VSS VSS gf180mcu_fd_sc_mcu7t5v0__nand3_1
XTAP_TAPCELL_ROW_40_594 VDD VSS gf180mcu_fd_sc_mcu7t5v0__filltie
XFILLER_57_419 VDD VDD VSS VSS gf180mcu_fd_sc_mcu7t5v0__fill_1
XFILLER_37_132 VDD VDD VSS VSS gf180mcu_fd_sc_mcu7t5v0__fillcap_8
X_1215_ _1230_/A1 _1213_/Z _1215_/A3 _2136_/D VDD VDD VSS VSS gf180mcu_fd_sc_mcu7t5v0__nor3_1
XFILLER_37_165 VDD VDD VSS VSS gf180mcu_fd_sc_mcu7t5v0__fillcap_4
X_1146_ _1146_/A1 _2164_/Q _1303_/A1 _2100_/Q _1147_/A2 VDD VDD VSS VSS gf180mcu_fd_sc_mcu7t5v0__aoi22_1
XFILLER_25_349 VDD VDD VSS VSS gf180mcu_fd_sc_mcu7t5v0__fill_1
XTAP_TAPCELL_ROW_48_672 VDD VSS gf180mcu_fd_sc_mcu7t5v0__filltie
XFILLER_53_647 VDD VDD VSS VSS gf180mcu_fd_sc_mcu7t5v0__fillcap_32
X_1077_ _2085_/Q _1253_/A1 _1270_/A1 _2089_/Q _1080_/A2 VDD VDD VSS VSS gf180mcu_fd_sc_mcu7t5v0__aoi22_1
XFILLER_21_500 VDD VDD VSS VSS gf180mcu_fd_sc_mcu7t5v0__fillcap_4
XFILLER_80_499 VDD VDD VSS VSS gf180mcu_fd_sc_mcu7t5v0__fill_2
XFILLER_61_680 VDD VDD VSS VSS gf180mcu_fd_sc_mcu7t5v0__fillcap_8
X_1979_ _1979_/D _2115_/RN clkload1/I _1979_/Q VDD VDD VSS VSS gf180mcu_fd_sc_mcu7t5v0__dffrnq_1
XTAP_TAPCELL_ROW_93_1092 VDD VSS gf180mcu_fd_sc_mcu7t5v0__filltie
XTAP_TAPCELL_ROW_3_242 VDD VSS gf180mcu_fd_sc_mcu7t5v0__filltie
XTAP_TAPCELL_ROW_74_918 VDD VSS gf180mcu_fd_sc_mcu7t5v0__filltie
XFILLER_83_282 VDD VDD VSS VSS gf180mcu_fd_sc_mcu7t5v0__fillcap_4
XFILLER_71_422 VDD VDD VSS VSS gf180mcu_fd_sc_mcu7t5v0__fill_1
XFILLER_45_88 VDD VDD VSS VSS gf180mcu_fd_sc_mcu7t5v0__fillcap_8
XFILLER_43_135 VDD VDD VSS VSS gf180mcu_fd_sc_mcu7t5v0__fillcap_4
XTAP_TAPCELL_ROW_82_995 VDD VSS gf180mcu_fd_sc_mcu7t5v0__filltie
XFILLER_12_522 VDD VDD VSS VSS gf180mcu_fd_sc_mcu7t5v0__fill_2
XFILLER_24_382 VDD VDD VSS VSS gf180mcu_fd_sc_mcu7t5v0__fill_2
XFILLER_24_393 VDD VDD VSS VSS gf180mcu_fd_sc_mcu7t5v0__fill_1
XFILLER_8_559 VDD VDD VSS VSS gf180mcu_fd_sc_mcu7t5v0__fillcap_8
XFILLER_79_566 VDD VDD VSS VSS gf180mcu_fd_sc_mcu7t5v0__fill_2
Xclkbuf_5_6__f_sys_clk_i clkbuf_4_3_0_sys_clk_i/Z _2018_/CLK VDD VDD VSS VSS gf180mcu_fd_sc_mcu7t5v0__clkbuf_16
X_1000_ _2124_/D _2125_/D _1000_/Z VDD VDD VSS VSS gf180mcu_fd_sc_mcu7t5v0__and2_1
XFILLER_81_208 VDD VDD VSS VSS gf180mcu_fd_sc_mcu7t5v0__fill_2
XTAP_TAPCELL_ROW_45_642 VDD VSS gf180mcu_fd_sc_mcu7t5v0__filltie
XFILLER_22_308 VDD VDD VSS VSS gf180mcu_fd_sc_mcu7t5v0__fillcap_4
XTAP_TAPCELL_ROW_17_377 VDD VSS gf180mcu_fd_sc_mcu7t5v0__filltie
XFILLER_50_639 VDD VDD VSS VSS gf180mcu_fd_sc_mcu7t5v0__fillcap_16
X_1902_ _1902_/D _1918_/RN clkload5/I _1902_/Q VDD VDD VSS VSS gf180mcu_fd_sc_mcu7t5v0__dffrnq_1
XFILLER_30_374 VDD VDD VSS VSS gf180mcu_fd_sc_mcu7t5v0__fillcap_8
X_1833_ _1834_/A2 _1833_/A2 _2082_/Q _1834_/B VDD VDD VSS VSS gf180mcu_fd_sc_mcu7t5v0__nand3_1
X_1764_ _1821_/A2 _1920_/Q _1766_/A2 VDD VDD VSS VSS gf180mcu_fd_sc_mcu7t5v0__nand2_1
Xhold515 _2122_/Q _2118_/D VDD VDD VSS VSS gf180mcu_fd_sc_mcu7t5v0__dlyc_1
Xhold526 _2106_/Q _2107_/D VDD VDD VSS VSS gf180mcu_fd_sc_mcu7t5v0__dlyc_1
X_1695_ _1738_/A1 _2064_/Q _1730_/A2 _2102_/Q _1696_/A2 VDD VDD VSS VSS gf180mcu_fd_sc_mcu7t5v0__aoi22_1
Xmax_cap278 _1509_/S _1508_/S VDD VDD VSS VSS gf180mcu_fd_sc_mcu7t5v0__buf_2
XFILLER_97_352 VDD VDD VSS VSS gf180mcu_fd_sc_mcu7t5v0__fill_2
XFILLER_85_536 VDD VDD VSS VSS gf180mcu_fd_sc_mcu7t5v0__fill_2
XTAP_TAPCELL_ROW_0_212 VDD VSS gf180mcu_fd_sc_mcu7t5v0__filltie
XTAP_TAPCELL_ROW_0_201 VDD VSS gf180mcu_fd_sc_mcu7t5v0__filltie
X_2178_ _2182_/Q _2193_/RN _2189_/CLK _2178_/Q VDD VDD VSS VSS gf180mcu_fd_sc_mcu7t5v0__dffrnq_1
XTAP_TAPCELL_ROW_84_1014 VDD VSS gf180mcu_fd_sc_mcu7t5v0__filltie
XFILLER_65_282 VDD VDD VSS VSS gf180mcu_fd_sc_mcu7t5v0__fillcap_16
XFILLER_65_271 VDD VDD VSS VSS gf180mcu_fd_sc_mcu7t5v0__fillcap_8
XFILLER_53_422 VDD VDD VSS VSS gf180mcu_fd_sc_mcu7t5v0__fillcap_32
X_1129_ _1129_/A1 _1129_/A2 _1147_/A4 _1130_/A3 VDD VDD VSS VSS gf180mcu_fd_sc_mcu7t5v0__nand3_1
XFILLER_80_241 VDD VDD VSS VSS gf180mcu_fd_sc_mcu7t5v0__fillcap_4
XFILLER_41_606 VDD VDD VSS VSS gf180mcu_fd_sc_mcu7t5v0__fillcap_4
XFILLER_80_263 VDD VDD VSS VSS gf180mcu_fd_sc_mcu7t5v0__fillcap_4
XFILLER_41_628 VDD VDD VSS VSS gf180mcu_fd_sc_mcu7t5v0__fill_2
XFILLER_15_69 VDD VDD VSS VSS gf180mcu_fd_sc_mcu7t5v0__fill_1
XFILLER_80_296 VDD VDD VSS VSS gf180mcu_fd_sc_mcu7t5v0__fillcap_8
XFILLER_21_352 VDD VDD VSS VSS gf180mcu_fd_sc_mcu7t5v0__fillcap_4
XFILLER_31_68 VDD VDD VSS VSS gf180mcu_fd_sc_mcu7t5v0__fill_2
Xinput102 data_tx_i[0] _1569_/I0 VDD VDD VSS VSS gf180mcu_fd_sc_mcu7t5v0__dlyb_1
XFILLER_88_341 VDD VDD VSS VSS gf180mcu_fd_sc_mcu7t5v0__fill_1
XFILLER_88_374 VDD VDD VSS VSS gf180mcu_fd_sc_mcu7t5v0__fillcap_8
XFILLER_56_98 VDD VDD VSS VSS gf180mcu_fd_sc_mcu7t5v0__fillcap_4
XPHY_EDGE_ROW_19_Right_19 VDD VSS gf180mcu_fd_sc_mcu7t5v0__endcap
XFILLER_44_444 VDD VDD VSS VSS gf180mcu_fd_sc_mcu7t5v0__fill_2
XFILLER_44_433 VDD VDD VSS VSS gf180mcu_fd_sc_mcu7t5v0__fill_2
XTAP_TAPCELL_ROW_42_612 VDD VSS gf180mcu_fd_sc_mcu7t5v0__filltie
XFILLER_12_341 VDD VDD VSS VSS gf180mcu_fd_sc_mcu7t5v0__fillcap_4
XTAP_TAPCELL_ROW_14_347 VDD VSS gf180mcu_fd_sc_mcu7t5v0__filltie
Xudma_uart_top_485 data_rx_o[9] VDD VDD VSS VSS gf180mcu_fd_sc_mcu7t5v0__tiel
XFILLER_8_389 VDD VDD VSS VSS gf180mcu_fd_sc_mcu7t5v0__fill_1
Xudma_uart_top_496 data_rx_o[20] VDD VDD VSS VSS gf180mcu_fd_sc_mcu7t5v0__tiel
XPHY_EDGE_ROW_28_Right_28 VDD VSS gf180mcu_fd_sc_mcu7t5v0__endcap
X_1480_ _1499_/A1 _1905_/Q _1482_/B VDD VDD VSS VSS gf180mcu_fd_sc_mcu7t5v0__nand2_1
XFILLER_98_138 VDD VDD VSS VSS gf180mcu_fd_sc_mcu7t5v0__fillcap_32
XFILLER_97_72 VDD VDD VSS VSS gf180mcu_fd_sc_mcu7t5v0__fillcap_64
X_2101_ _2101_/D _2101_/RN _2188_/CLK _2101_/Q VDD VDD VSS VSS gf180mcu_fd_sc_mcu7t5v0__dffrnq_1
XFILLER_94_333 VDD VDD VSS VSS gf180mcu_fd_sc_mcu7t5v0__fillcap_8
X_2032_ _2032_/D _2032_/RN clkload0/I _2032_/Q VDD VDD VSS VSS gf180mcu_fd_sc_mcu7t5v0__dffrnq_1
XFILLER_35_422 VDD VDD VSS VSS gf180mcu_fd_sc_mcu7t5v0__fillcap_16
XPHY_EDGE_ROW_37_Right_37 VDD VSS gf180mcu_fd_sc_mcu7t5v0__endcap
XFILLER_90_550 VDD VDD VSS VSS gf180mcu_fd_sc_mcu7t5v0__fillcap_8
XFILLER_62_263 VDD VDD VSS VSS gf180mcu_fd_sc_mcu7t5v0__fillcap_4
XFILLER_50_403 VDD VDD VSS VSS gf180mcu_fd_sc_mcu7t5v0__fill_2
XFILLER_30_193 VDD VDD VSS VSS gf180mcu_fd_sc_mcu7t5v0__fillcap_32
X_1816_ _1816_/A1 _1816_/A2 _1817_/A2 VDD VDD VSS VSS gf180mcu_fd_sc_mcu7t5v0__nand2_1
XPHY_EDGE_ROW_46_Right_46 VDD VSS gf180mcu_fd_sc_mcu7t5v0__endcap
X_1747_ _1757_/A1 _1747_/A2 _1747_/A3 _1747_/Z VDD VDD VSS VSS gf180mcu_fd_sc_mcu7t5v0__and3_1
X_1678_ _2044_/Q _1306_/Z _1678_/S _2044_/D VDD VDD VSS VSS gf180mcu_fd_sc_mcu7t5v0__mux2_2
XFILLER_98_672 VDD VDD VSS VSS gf180mcu_fd_sc_mcu7t5v0__fillcap_8
XPHY_EDGE_ROW_55_Right_55 VDD VSS gf180mcu_fd_sc_mcu7t5v0__endcap
XFILLER_26_24 VDD VDD VSS VSS gf180mcu_fd_sc_mcu7t5v0__fill_2
XTAP_TAPCELL_ROW_56_748 VDD VSS gf180mcu_fd_sc_mcu7t5v0__filltie
Xclkbuf_5_25__f_sys_clk_i clkbuf_4_12_0_sys_clk_i/Z _1921_/CLK VDD VDD VSS VSS gf180mcu_fd_sc_mcu7t5v0__clkbuf_16
XTAP_TAPCELL_ROW_11_317 VDD VSS gf180mcu_fd_sc_mcu7t5v0__filltie
XPHY_EDGE_ROW_64_Right_64 VDD VSS gf180mcu_fd_sc_mcu7t5v0__endcap
XFILLER_42_78 VDD VDD VSS VSS gf180mcu_fd_sc_mcu7t5v0__fillcap_16
XPHY_EDGE_ROW_73_Right_73 VDD VSS gf180mcu_fd_sc_mcu7t5v0__endcap
XFILLER_88_171 VDD VDD VSS VSS gf180mcu_fd_sc_mcu7t5v0__fillcap_4
XFILLER_29_260 VDD VDD VSS VSS gf180mcu_fd_sc_mcu7t5v0__fill_2
XFILLER_29_282 VDD VDD VSS VSS gf180mcu_fd_sc_mcu7t5v0__fillcap_32
XFILLER_44_230 VDD VDD VSS VSS gf180mcu_fd_sc_mcu7t5v0__fill_2
XTAP_TAPCELL_ROW_27_472 VDD VSS gf180mcu_fd_sc_mcu7t5v0__filltie
X_0980_ _0982_/A1 _1332_/A3 _1319_/B _0983_/A3 VDD VDD VSS VSS gf180mcu_fd_sc_mcu7t5v0__nor3_1
XPHY_EDGE_ROW_82_Right_82 VDD VSS gf180mcu_fd_sc_mcu7t5v0__endcap
XFILLER_9_632 VDD VDD VSS VSS gf180mcu_fd_sc_mcu7t5v0__fillcap_32
X_1601_ _1975_/Q input30/Z _1601_/S _1975_/D VDD VDD VSS VSS gf180mcu_fd_sc_mcu7t5v0__mux2_2
X_1532_ _1532_/A1 _1932_/Q _2120_/Q _1933_/Q _1540_/A3 VDD VDD VSS VSS gf180mcu_fd_sc_mcu7t5v0__nand4_1
X_1463_ _1462_/Z _1898_/Q _1473_/S _1898_/D VDD VDD VSS VSS gf180mcu_fd_sc_mcu7t5v0__mux2_2
XPHY_EDGE_ROW_91_Right_91 VDD VSS gf180mcu_fd_sc_mcu7t5v0__endcap
X_1394_ _1394_/A1 _1394_/A2 _1394_/ZN VDD VDD VSS VSS gf180mcu_fd_sc_mcu7t5v0__nand2_1
XFILLER_95_664 VDD VDD VSS VSS gf180mcu_fd_sc_mcu7t5v0__fillcap_16
XFILLER_82_314 VDD VDD VSS VSS gf180mcu_fd_sc_mcu7t5v0__fill_1
X_2015_ _2015_/D _2028_/RN clkload0/I _2015_/Q VDD VDD VSS VSS gf180mcu_fd_sc_mcu7t5v0__dffrnq_1
XTAP_TAPCELL_ROW_53_718 VDD VSS gf180mcu_fd_sc_mcu7t5v0__filltie
XFILLER_50_255 VDD VDD VSS VSS gf180mcu_fd_sc_mcu7t5v0__fill_2
XTAP_TAPCELL_ROW_61_795 VDD VSS gf180mcu_fd_sc_mcu7t5v0__filltie
XFILLER_12_37 VDD VDD VSS VSS gf180mcu_fd_sc_mcu7t5v0__fillcap_64
XFILLER_58_311 VDD VDD VSS VSS gf180mcu_fd_sc_mcu7t5v0__fillcap_4
XFILLER_37_67 VDD VDD VSS VSS gf180mcu_fd_sc_mcu7t5v0__fill_2
XFILLER_54_594 VDD VDD VSS VSS gf180mcu_fd_sc_mcu7t5v0__fill_1
XFILLER_53_44 VDD VDD VSS VSS gf180mcu_fd_sc_mcu7t5v0__fillcap_16
XTAP_TAPCELL_ROW_24_442 VDD VSS gf180mcu_fd_sc_mcu7t5v0__filltie
XFILLER_41_277 VDD VDD VSS VSS gf180mcu_fd_sc_mcu7t5v0__fill_2
Xclkbuf_4_8_0_periph_clk_i clkbuf_0_periph_clk_i/Z clkbuf_4_8_0_periph_clk_i/Z VDD
+ VDD VSS VSS gf180mcu_fd_sc_mcu7t5v0__clkbuf_2
XFILLER_6_679 VDD VDD VSS VSS gf180mcu_fd_sc_mcu7t5v0__fill_2
XFILLER_49_333 VDD VDD VSS VSS gf180mcu_fd_sc_mcu7t5v0__fillcap_8
XFILLER_49_300 VDD VDD VSS VSS gf180mcu_fd_sc_mcu7t5v0__fill_1
XFILLER_64_325 VDD VDD VSS VSS gf180mcu_fd_sc_mcu7t5v0__fillcap_4
XFILLER_92_667 VDD VDD VSS VSS gf180mcu_fd_sc_mcu7t5v0__fillcap_16
XFILLER_17_241 VDD VDD VSS VSS gf180mcu_fd_sc_mcu7t5v0__fill_2
XFILLER_32_244 VDD VDD VSS VSS gf180mcu_fd_sc_mcu7t5v0__fill_1
XFILLER_60_597 VDD VDD VSS VSS gf180mcu_fd_sc_mcu7t5v0__fillcap_64
XFILLER_13_480 VDD VDD VSS VSS gf180mcu_fd_sc_mcu7t5v0__fillcap_8
X_0963_ _0963_/A1 _2041_/Q _0963_/Z VDD VDD VSS VSS gf180mcu_fd_sc_mcu7t5v0__and2_1
XFILLER_64_2 VDD VDD VSS VSS gf180mcu_fd_sc_mcu7t5v0__fillcap_8
Xoutput214 _1312_/Z wire286/I VDD VDD VSS VSS gf180mcu_fd_sc_mcu7t5v0__buf_1
Xoutput203 _2013_/Q wire357/I VDD VDD VSS VSS gf180mcu_fd_sc_mcu7t5v0__buf_1
X_1515_ _1521_/A1 _1515_/A2 _1515_/B _1921_/D VDD VDD VSS VSS gf180mcu_fd_sc_mcu7t5v0__oai21_1
X_1446_ _2042_/Q _2040_/Q _1446_/Z VDD VDD VSS VSS gf180mcu_fd_sc_mcu7t5v0__or2_1
X_1377_ _1377_/A1 _1377_/A2 _1378_/A1 VDD VDD VSS VSS gf180mcu_fd_sc_mcu7t5v0__nand2_1
XFILLER_67_152 VDD VDD VSS VSS gf180mcu_fd_sc_mcu7t5v0__fill_1
XFILLER_55_314 VDD VDD VSS VSS gf180mcu_fd_sc_mcu7t5v0__fillcap_8
XTAP_TAPCELL_ROW_66_843 VDD VSS gf180mcu_fd_sc_mcu7t5v0__filltie
XTAP_TAPCELL_ROW_38_578 VDD VSS gf180mcu_fd_sc_mcu7t5v0__filltie
XFILLER_82_177 VDD VDD VSS VSS gf180mcu_fd_sc_mcu7t5v0__fillcap_32
XFILLER_70_317 VDD VDD VSS VSS gf180mcu_fd_sc_mcu7t5v0__fillcap_64
XFILLER_36_594 VDD VDD VSS VSS gf180mcu_fd_sc_mcu7t5v0__fill_1
XTAP_TAPCELL_ROW_21_412 VDD VSS gf180mcu_fd_sc_mcu7t5v0__filltie
Xwire308 wire308/I cfg_data_o[17] VDD VDD VSS VSS gf180mcu_fd_sc_mcu7t5v0__clkbuf_3
Xfanout430 input4/Z _1195_/A1 VDD VDD VSS VSS gf180mcu_fd_sc_mcu7t5v0__dlyb_1
Xfanout441 _2020_/RN _1959_/RN VDD VDD VSS VSS gf180mcu_fd_sc_mcu7t5v0__dlyb_1
XFILLER_78_439 VDD VDD VSS VSS gf180mcu_fd_sc_mcu7t5v0__fillcap_16
Xfanout463 _2176_/RN _2079_/RN VDD VDD VSS VSS gf180mcu_fd_sc_mcu7t5v0__buf_1
Xfanout474 _2097_/RN _1963_/RN VDD VDD VSS VSS gf180mcu_fd_sc_mcu7t5v0__dlyb_1
XFILLER_59_664 VDD VDD VSS VSS gf180mcu_fd_sc_mcu7t5v0__fillcap_16
XFILLER_74_601 VDD VDD VSS VSS gf180mcu_fd_sc_mcu7t5v0__fill_1
XFILLER_58_174 VDD VDD VSS VSS gf180mcu_fd_sc_mcu7t5v0__fill_1
XFILLER_46_314 VDD VDD VSS VSS gf180mcu_fd_sc_mcu7t5v0__fill_1
XFILLER_74_667 VDD VDD VSS VSS gf180mcu_fd_sc_mcu7t5v0__fillcap_16
XFILLER_74_645 VDD VDD VSS VSS gf180mcu_fd_sc_mcu7t5v0__fillcap_16
XFILLER_64_10 VDD VDD VSS VSS gf180mcu_fd_sc_mcu7t5v0__fillcap_4
XFILLER_34_509 VDD VDD VSS VSS gf180mcu_fd_sc_mcu7t5v0__fill_2
XFILLER_46_369 VDD VDD VSS VSS gf180mcu_fd_sc_mcu7t5v0__fillcap_8
XFILLER_27_594 VDD VDD VSS VSS gf180mcu_fd_sc_mcu7t5v0__fill_2
XFILLER_42_520 VDD VDD VSS VSS gf180mcu_fd_sc_mcu7t5v0__fillcap_4
XFILLER_42_542 VDD VDD VSS VSS gf180mcu_fd_sc_mcu7t5v0__fillcap_4
XFILLER_69_417 VDD VDD VSS VSS gf180mcu_fd_sc_mcu7t5v0__fill_2
XFILLER_2_693 VDD VDD VSS VSS gf180mcu_fd_sc_mcu7t5v0__fill_1
X_1300_ _2175_/Q _1300_/A2 _1288_/Z _1300_/A4 _1302_/A2 VDD VDD VSS VSS gf180mcu_fd_sc_mcu7t5v0__nand4_1
X_1231_ _2140_/Q _1226_/Z _2141_/Q _1234_/A2 VDD VDD VSS VSS gf180mcu_fd_sc_mcu7t5v0__aoi21_1
XFILLER_96_247 VDD VDD VSS VSS gf180mcu_fd_sc_mcu7t5v0__fillcap_16
XFILLER_77_450 VDD VDD VSS VSS gf180mcu_fd_sc_mcu7t5v0__fill_2
XFILLER_37_314 VDD VDD VSS VSS gf180mcu_fd_sc_mcu7t5v0__fill_2
X_1162_ _2053_/Q _1703_/C _1703_/B _1163_/B VDD VDD VSS VSS gf180mcu_fd_sc_mcu7t5v0__oai21_1
X_1093_ _2090_/Q _2166_/Q _1096_/A2 VDD VDD VSS VSS gf180mcu_fd_sc_mcu7t5v0__nand2_1
XTAP_TAPCELL_ROW_63_813 VDD VSS gf180mcu_fd_sc_mcu7t5v0__filltie
XFILLER_64_177 VDD VDD VSS VSS gf180mcu_fd_sc_mcu7t5v0__fillcap_8
XFILLER_52_317 VDD VDD VSS VSS gf180mcu_fd_sc_mcu7t5v0__fillcap_8
XTAP_TAPCELL_ROW_35_548 VDD VSS gf180mcu_fd_sc_mcu7t5v0__filltie
XFILLER_20_247 VDD VDD VSS VSS gf180mcu_fd_sc_mcu7t5v0__fillcap_8
X_1995_ _1995_/D _2028_/RN _2020_/CLK _1995_/Q VDD VDD VSS VSS gf180mcu_fd_sc_mcu7t5v0__dffrnq_1
XTAP_TAPCELL_ROW_71_890 VDD VSS gf180mcu_fd_sc_mcu7t5v0__filltie
X_0946_ _2175_/Q _1303_/A1 VDD VDD VSS VSS gf180mcu_fd_sc_mcu7t5v0__clkinv_1
X_1429_ _1876_/Q _2060_/Q _1432_/S _1876_/D VDD VDD VSS VSS gf180mcu_fd_sc_mcu7t5v0__mux2_2
XFILLER_75_409 VDD VDD VSS VSS gf180mcu_fd_sc_mcu7t5v0__fill_2
XFILLER_68_450 VDD VDD VSS VSS gf180mcu_fd_sc_mcu7t5v0__fillcap_4
XFILLER_28_314 VDD VDD VSS VSS gf180mcu_fd_sc_mcu7t5v0__fill_1
XFILLER_56_645 VDD VDD VSS VSS gf180mcu_fd_sc_mcu7t5v0__fillcap_16
XFILLER_56_667 VDD VDD VSS VSS gf180mcu_fd_sc_mcu7t5v0__fillcap_16
XFILLER_11_214 VDD VDD VSS VSS gf180mcu_fd_sc_mcu7t5v0__fill_1
XFILLER_24_597 VDD VDD VSS VSS gf180mcu_fd_sc_mcu7t5v0__fill_2
Xclkload1 clkload1/I clkload1/Z VDD VDD VSS VSS gf180mcu_fd_sc_mcu7t5v0__clkbuf_2
XTAP_TAPCELL_ROW_98_1152 VDD VSS gf180mcu_fd_sc_mcu7t5v0__filltie
XTAP_TAPCELL_ROW_98_1141 VDD VSS gf180mcu_fd_sc_mcu7t5v0__filltie
XFILLER_50_45 VDD VDD VSS VSS gf180mcu_fd_sc_mcu7t5v0__fill_1
XFILLER_50_34 VDD VDD VSS VSS gf180mcu_fd_sc_mcu7t5v0__fill_1
XFILLER_50_89 VDD VDD VSS VSS gf180mcu_fd_sc_mcu7t5v0__fillcap_8
XFILLER_59_76 VDD VDD VSS VSS gf180mcu_fd_sc_mcu7t5v0__fill_2
XFILLER_78_247 VDD VDD VSS VSS gf180mcu_fd_sc_mcu7t5v0__fillcap_16
Xfanout260 _1648_/ZN _1652_/S VDD VDD VSS VSS gf180mcu_fd_sc_mcu7t5v0__dlyb_1
XTAP_TAPCELL_ROW_6_273 VDD VSS gf180mcu_fd_sc_mcu7t5v0__filltie
XFILLER_93_206 VDD VDD VSS VSS gf180mcu_fd_sc_mcu7t5v0__fillcap_4
XFILLER_46_166 VDD VDD VSS VSS gf180mcu_fd_sc_mcu7t5v0__fillcap_8
XFILLER_74_497 VDD VDD VSS VSS gf180mcu_fd_sc_mcu7t5v0__fillcap_4
XFILLER_46_199 VDD VDD VSS VSS gf180mcu_fd_sc_mcu7t5v0__fill_1
XTAP_TAPCELL_ROW_32_518 VDD VSS gf180mcu_fd_sc_mcu7t5v0__filltie
X_1780_ _1821_/A2 _1922_/Q _1782_/A2 VDD VDD VSS VSS gf180mcu_fd_sc_mcu7t5v0__nand2_1
XTAP_TAPCELL_ROW_40_595 VDD VSS gf180mcu_fd_sc_mcu7t5v0__filltie
XFILLER_38_601 VDD VDD VSS VSS gf180mcu_fd_sc_mcu7t5v0__fill_2
XFILLER_1_50 VDD VDD VSS VSS gf180mcu_fd_sc_mcu7t5v0__fillcap_4
XFILLER_37_122 VDD VDD VSS VSS gf180mcu_fd_sc_mcu7t5v0__fill_2
X_2194_ _2194_/D _2194_/RN _2194_/CLK _2194_/Q VDD VDD VSS VSS gf180mcu_fd_sc_mcu7t5v0__dffrnq_1
X_1214_ _2135_/Q _1208_/Z _2136_/Q _1215_/A3 VDD VDD VSS VSS gf180mcu_fd_sc_mcu7t5v0__aoi21_1
XFILLER_1_72 VDD VDD VSS VSS gf180mcu_fd_sc_mcu7t5v0__fillcap_4
X_1145_ _1145_/A1 _2165_/Q _1270_/A2 _2091_/Q _1147_/A1 VDD VDD VSS VSS gf180mcu_fd_sc_mcu7t5v0__aoi22_1
XTAP_TAPCELL_ROW_48_673 VDD VSS gf180mcu_fd_sc_mcu7t5v0__filltie
X_1076_ _1076_/A1 _2161_/Q _1148_/A1 _2162_/Q _1080_/A1 VDD VDD VSS VSS gf180mcu_fd_sc_mcu7t5v0__aoi22_1
XFILLER_80_478 VDD VDD VSS VSS gf180mcu_fd_sc_mcu7t5v0__fill_1
XFILLER_21_545 VDD VDD VSS VSS gf180mcu_fd_sc_mcu7t5v0__fillcap_8
XFILLER_33_394 VDD VDD VSS VSS gf180mcu_fd_sc_mcu7t5v0__fill_1
XFILLER_61_692 VDD VDD VSS VSS gf180mcu_fd_sc_mcu7t5v0__fill_2
XFILLER_21_578 VDD VDD VSS VSS gf180mcu_fd_sc_mcu7t5v0__fill_2
X_1978_ _1978_/D _2028_/RN _2037_/CLK _1978_/Q VDD VDD VSS VSS gf180mcu_fd_sc_mcu7t5v0__dffrnq_1
X_0929_ _2053_/Q _1733_/A4 VDD VDD VSS VSS gf180mcu_fd_sc_mcu7t5v0__clkinv_1
XFILLER_20_37 VDD VDD VSS VSS gf180mcu_fd_sc_mcu7t5v0__fillcap_64
XTAP_TAPCELL_ROW_93_1093 VDD VSS gf180mcu_fd_sc_mcu7t5v0__filltie
XFILLER_88_512 VDD VDD VSS VSS gf180mcu_fd_sc_mcu7t5v0__fillcap_8
XFILLER_88_567 VDD VDD VSS VSS gf180mcu_fd_sc_mcu7t5v0__fillcap_16
XFILLER_28_111 VDD VDD VSS VSS gf180mcu_fd_sc_mcu7t5v0__fillcap_64
XTAP_TAPCELL_ROW_3_243 VDD VSS gf180mcu_fd_sc_mcu7t5v0__filltie
XFILLER_75_228 VDD VDD VSS VSS gf180mcu_fd_sc_mcu7t5v0__fillcap_4
XFILLER_68_280 VDD VDD VSS VSS gf180mcu_fd_sc_mcu7t5v0__fill_1
XTAP_TAPCELL_ROW_74_919 VDD VSS gf180mcu_fd_sc_mcu7t5v0__filltie
XFILLER_56_453 VDD VDD VSS VSS gf180mcu_fd_sc_mcu7t5v0__fill_2
XFILLER_16_317 VDD VDD VSS VSS gf180mcu_fd_sc_mcu7t5v0__fillcap_16
XFILLER_28_177 VDD VDD VSS VSS gf180mcu_fd_sc_mcu7t5v0__fillcap_4
XFILLER_43_103 VDD VDD VSS VSS gf180mcu_fd_sc_mcu7t5v0__fillcap_8
XFILLER_45_67 VDD VDD VSS VSS gf180mcu_fd_sc_mcu7t5v0__fill_2
XFILLER_43_158 VDD VDD VSS VSS gf180mcu_fd_sc_mcu7t5v0__fillcap_4
XFILLER_24_372 VDD VDD VSS VSS gf180mcu_fd_sc_mcu7t5v0__fill_2
XTAP_TAPCELL_ROW_82_996 VDD VSS gf180mcu_fd_sc_mcu7t5v0__filltie
XFILLER_52_681 VDD VDD VSS VSS gf180mcu_fd_sc_mcu7t5v0__fill_1
XFILLER_51_180 VDD VDD VSS VSS gf180mcu_fd_sc_mcu7t5v0__fillcap_16
XFILLER_8_527 VDD VDD VSS VSS gf180mcu_fd_sc_mcu7t5v0__fillcap_32
XTAP_TAPCELL_ROW_45_643 VDD VSS gf180mcu_fd_sc_mcu7t5v0__filltie
XTAP_TAPCELL_ROW_17_378 VDD VSS gf180mcu_fd_sc_mcu7t5v0__filltie
X_1901_ _1901_/D _1918_/RN clkload5/I _1901_/Q VDD VDD VSS VSS gf180mcu_fd_sc_mcu7t5v0__dffrnq_1
X_1832_ _2068_/Q _1832_/A2 _1832_/A3 _1833_/A2 VDD VDD VSS VSS gf180mcu_fd_sc_mcu7t5v0__nand3_1
X_1763_ _1826_/A1 _1829_/A3 _2072_/Q _1832_/A2 _1769_/C VDD VDD VSS VSS gf180mcu_fd_sc_mcu7t5v0__nand4_1
X_1694_ _1730_/A1 _2101_/Q _1696_/A3 VDD VDD VSS VSS gf180mcu_fd_sc_mcu7t5v0__nand2_1
Xhold516 _2190_/Q _2191_/D VDD VDD VSS VSS gf180mcu_fd_sc_mcu7t5v0__dlyc_1
XFILLER_7_593 VDD VDD VSS VSS gf180mcu_fd_sc_mcu7t5v0__fill_1
Xmax_cap279 _1510_/A2 _1497_/A1 VDD VDD VSS VSS gf180mcu_fd_sc_mcu7t5v0__buf_1
Xload_slew452 _2051_/RN _2115_/RN VDD VDD VSS VSS gf180mcu_fd_sc_mcu7t5v0__clkbuf_3
XFILLER_85_504 VDD VDD VSS VSS gf180mcu_fd_sc_mcu7t5v0__fillcap_32
XFILLER_97_397 VDD VDD VSS VSS gf180mcu_fd_sc_mcu7t5v0__fill_2
XFILLER_85_559 VDD VDD VSS VSS gf180mcu_fd_sc_mcu7t5v0__fill_1
XFILLER_57_228 VDD VDD VSS VSS gf180mcu_fd_sc_mcu7t5v0__fillcap_4
XTAP_TAPCELL_ROW_0_202 VDD VSS gf180mcu_fd_sc_mcu7t5v0__filltie
X_2177_ _2179_/Q _2185_/RN clkload3/I _2181_/D VDD VDD VSS VSS gf180mcu_fd_sc_mcu7t5v0__dffrnq_1
XTAP_TAPCELL_ROW_84_1015 VDD VSS gf180mcu_fd_sc_mcu7t5v0__filltie
XTAP_TAPCELL_ROW_0_213 VDD VSS gf180mcu_fd_sc_mcu7t5v0__filltie
XFILLER_25_136 VDD VDD VSS VSS gf180mcu_fd_sc_mcu7t5v0__fillcap_4
XFILLER_25_158 VDD VDD VSS VSS gf180mcu_fd_sc_mcu7t5v0__fillcap_8
X_1128_ _2087_/Q _1253_/A2 _1270_/A2 _2091_/Q _1129_/A2 VDD VDD VSS VSS gf180mcu_fd_sc_mcu7t5v0__aoi22_1
X_1059_ _1415_/A3 _1406_/A2 _1059_/B _1062_/A2 VDD VDD VSS VSS gf180mcu_fd_sc_mcu7t5v0__aoi21_1
XFILLER_53_478 VDD VDD VSS VSS gf180mcu_fd_sc_mcu7t5v0__fillcap_4
XFILLER_21_386 VDD VDD VSS VSS gf180mcu_fd_sc_mcu7t5v0__fill_1
XFILLER_31_58 VDD VDD VSS VSS gf180mcu_fd_sc_mcu7t5v0__fillcap_4
XTAP_TAPCELL_ROW_95_1111 VDD VSS gf180mcu_fd_sc_mcu7t5v0__filltie
Xinput103 data_tx_i[1] _1570_/I0 VDD VDD VSS VSS gf180mcu_fd_sc_mcu7t5v0__dlyb_1
XFILLER_48_228 VDD VDD VSS VSS gf180mcu_fd_sc_mcu7t5v0__fill_2
XFILLER_56_33 VDD VDD VSS VSS gf180mcu_fd_sc_mcu7t5v0__fill_2
XTAP_TAPCELL_ROW_42_613 VDD VSS gf180mcu_fd_sc_mcu7t5v0__filltie
XFILLER_31_139 VDD VDD VSS VSS gf180mcu_fd_sc_mcu7t5v0__fill_1
XTAP_TAPCELL_ROW_14_348 VDD VSS gf180mcu_fd_sc_mcu7t5v0__filltie
XFILLER_72_98 VDD VDD VSS VSS gf180mcu_fd_sc_mcu7t5v0__fillcap_4
XTAP_TAPCELL_ROW_50_690 VDD VSS gf180mcu_fd_sc_mcu7t5v0__filltie
Xudma_uart_top_497 data_rx_o[21] VDD VDD VSS VSS gf180mcu_fd_sc_mcu7t5v0__tiel
Xudma_uart_top_486 data_rx_o[10] VDD VDD VSS VSS gf180mcu_fd_sc_mcu7t5v0__tiel
X_2100_ _2100_/D _2174_/RN _2100_/CLK _2100_/Q VDD VDD VSS VSS gf180mcu_fd_sc_mcu7t5v0__dffrnq_1
XFILLER_79_386 VDD VDD VSS VSS gf180mcu_fd_sc_mcu7t5v0__fillcap_16
XFILLER_67_559 VDD VDD VSS VSS gf180mcu_fd_sc_mcu7t5v0__fill_1
X_2031_ _2031_/D _2031_/RN _2031_/CLK _2031_/Q VDD VDD VSS VSS gf180mcu_fd_sc_mcu7t5v0__dffrnq_1
XFILLER_75_570 VDD VDD VSS VSS gf180mcu_fd_sc_mcu7t5v0__fill_1
XFILLER_94_2 VDD VDD VSS VSS gf180mcu_fd_sc_mcu7t5v0__fillcap_32
XFILLER_30_172 VDD VDD VSS VSS gf180mcu_fd_sc_mcu7t5v0__fill_2
X_1815_ _1815_/A1 _1910_/Q _1902_/Q _1815_/B2 _1815_/C _1817_/A1 VDD VDD VSS VSS gf180mcu_fd_sc_mcu7t5v0__aoi221_1
X_1746_ _1754_/B1 _2083_/Q _1746_/B _1747_/A3 VDD VDD VSS VSS gf180mcu_fd_sc_mcu7t5v0__oai21_1
XFILLER_7_82 VDD VDD VSS VSS gf180mcu_fd_sc_mcu7t5v0__fill_1
X_1677_ _2043_/Q _1305_/Z _1682_/S _2043_/D VDD VDD VSS VSS gf180mcu_fd_sc_mcu7t5v0__mux2_2
XTAP_TAPCELL_ROW_90_1063 VDD VSS gf180mcu_fd_sc_mcu7t5v0__filltie
Xload_slew282 _1433_/B _1445_/S VDD VDD VSS VSS gf180mcu_fd_sc_mcu7t5v0__buf_2
Xload_slew271 _1596_/S _1600_/S VDD VDD VSS VSS gf180mcu_fd_sc_mcu7t5v0__buf_2
XFILLER_85_367 VDD VDD VSS VSS gf180mcu_fd_sc_mcu7t5v0__fill_1
XTAP_TAPCELL_ROW_56_749 VDD VSS gf180mcu_fd_sc_mcu7t5v0__filltie
XFILLER_66_592 VDD VDD VSS VSS gf180mcu_fd_sc_mcu7t5v0__fill_2
XFILLER_26_489 VDD VDD VSS VSS gf180mcu_fd_sc_mcu7t5v0__fillcap_16
XFILLER_81_562 VDD VDD VSS VSS gf180mcu_fd_sc_mcu7t5v0__fillcap_8
XFILLER_13_128 VDD VDD VSS VSS gf180mcu_fd_sc_mcu7t5v0__fillcap_4
XTAP_TAPCELL_ROW_11_318 VDD VSS gf180mcu_fd_sc_mcu7t5v0__filltie
XPHY_EDGE_ROW_2_Left_101 VDD VSS gf180mcu_fd_sc_mcu7t5v0__endcap
XPHY_EDGE_ROW_39_Left_138 VDD VSS gf180mcu_fd_sc_mcu7t5v0__endcap
XFILLER_5_349 VDD VDD VSS VSS gf180mcu_fd_sc_mcu7t5v0__fill_1
XFILLER_76_345 VDD VDD VSS VSS gf180mcu_fd_sc_mcu7t5v0__fillcap_8
XFILLER_17_401 VDD VDD VSS VSS gf180mcu_fd_sc_mcu7t5v0__fillcap_16
XPHY_EDGE_ROW_48_Left_147 VDD VSS gf180mcu_fd_sc_mcu7t5v0__endcap
XFILLER_57_570 VDD VDD VSS VSS gf180mcu_fd_sc_mcu7t5v0__fill_2
XFILLER_17_489 VDD VDD VSS VSS gf180mcu_fd_sc_mcu7t5v0__fill_1
XFILLER_32_437 VDD VDD VSS VSS gf180mcu_fd_sc_mcu7t5v0__fillcap_16
XTAP_TAPCELL_ROW_27_473 VDD VSS gf180mcu_fd_sc_mcu7t5v0__filltie
XFILLER_72_584 VDD VDD VSS VSS gf180mcu_fd_sc_mcu7t5v0__fill_1
X_1600_ _1974_/Q input29/Z _1600_/S _1974_/D VDD VDD VSS VSS gf180mcu_fd_sc_mcu7t5v0__mux2_2
XPHY_EDGE_ROW_57_Left_156 VDD VSS gf180mcu_fd_sc_mcu7t5v0__endcap
XFILLER_9_688 VDD VDD VSS VSS gf180mcu_fd_sc_mcu7t5v0__fillcap_4
X_1531_ _2125_/D _2124_/D _1531_/S _1931_/D VDD VDD VSS VSS gf180mcu_fd_sc_mcu7t5v0__mux2_2
XFILLER_4_360 VDD VDD VSS VSS gf180mcu_fd_sc_mcu7t5v0__fill_1
X_1462_ _1942_/Q _1950_/Q _1939_/Q _1462_/Z VDD VDD VSS VSS gf180mcu_fd_sc_mcu7t5v0__mux2_2
XFILLER_79_150 VDD VDD VSS VSS gf180mcu_fd_sc_mcu7t5v0__fill_2
X_1393_ input40/Z _1396_/A2 _1393_/B1 input56/Z _1394_/A2 VDD VDD VSS VSS gf180mcu_fd_sc_mcu7t5v0__aoi22_1
XFILLER_95_632 VDD VDD VSS VSS gf180mcu_fd_sc_mcu7t5v0__fillcap_32
XFILLER_67_312 VDD VDD VSS VSS gf180mcu_fd_sc_mcu7t5v0__fill_1
XPHY_EDGE_ROW_66_Left_165 VDD VSS gf180mcu_fd_sc_mcu7t5v0__endcap
X_2014_ _2014_/D _2034_/RN _2018_/CLK _2014_/Q VDD VDD VSS VSS gf180mcu_fd_sc_mcu7t5v0__dffrnq_1
XFILLER_48_592 VDD VDD VSS VSS gf180mcu_fd_sc_mcu7t5v0__fill_2
XTAP_TAPCELL_ROW_53_719 VDD VSS gf180mcu_fd_sc_mcu7t5v0__filltie
XFILLER_63_562 VDD VDD VSS VSS gf180mcu_fd_sc_mcu7t5v0__fillcap_8
XTAP_TAPCELL_ROW_61_796 VDD VSS gf180mcu_fd_sc_mcu7t5v0__filltie
XFILLER_31_492 VDD VDD VSS VSS gf180mcu_fd_sc_mcu7t5v0__fillcap_8
XPHY_EDGE_ROW_75_Left_174 VDD VSS gf180mcu_fd_sc_mcu7t5v0__endcap
XFILLER_2_319 VDD VDD VSS VSS gf180mcu_fd_sc_mcu7t5v0__fill_1
X_1729_ _1732_/A3 _1725_/Z _1718_/S _2065_/Q _1730_/B VDD VDD VSS VSS gf180mcu_fd_sc_mcu7t5v0__aoi22_1
XFILLER_77_109 VDD VDD VSS VSS gf180mcu_fd_sc_mcu7t5v0__fill_2
XPHY_EDGE_ROW_84_Left_183 VDD VSS gf180mcu_fd_sc_mcu7t5v0__endcap
XFILLER_85_142 VDD VDD VSS VSS gf180mcu_fd_sc_mcu7t5v0__fillcap_64
XFILLER_58_378 VDD VDD VSS VSS gf180mcu_fd_sc_mcu7t5v0__fillcap_4
XTAP_TAPCELL_ROW_24_443 VDD VSS gf180mcu_fd_sc_mcu7t5v0__filltie
XPHY_EDGE_ROW_93_Left_192 VDD VSS gf180mcu_fd_sc_mcu7t5v0__endcap
XFILLER_89_492 VDD VDD VSS VSS gf180mcu_fd_sc_mcu7t5v0__fillcap_32
XFILLER_78_86 VDD VDD VSS VSS gf180mcu_fd_sc_mcu7t5v0__fillcap_16
XFILLER_49_378 VDD VDD VSS VSS gf180mcu_fd_sc_mcu7t5v0__fill_1
XFILLER_17_220 VDD VDD VSS VSS gf180mcu_fd_sc_mcu7t5v0__fill_2
XFILLER_45_562 VDD VDD VSS VSS gf180mcu_fd_sc_mcu7t5v0__fillcap_16
XFILLER_60_521 VDD VDD VSS VSS gf180mcu_fd_sc_mcu7t5v0__fillcap_4
XFILLER_32_234 VDD VDD VSS VSS gf180mcu_fd_sc_mcu7t5v0__fillcap_8
X_0962_ _1671_/A1 _1669_/A1 _0963_/A1 VDD VDD VSS VSS gf180mcu_fd_sc_mcu7t5v0__nand2_1
Xoutput215 _0992_/ZN wire223/I VDD VDD VSS VSS gf180mcu_fd_sc_mcu7t5v0__buf_1
Xoutput204 _2014_/Q wire356/I VDD VDD VSS VSS gf180mcu_fd_sc_mcu7t5v0__buf_1
XFILLER_57_2 VDD VDD VSS VSS gf180mcu_fd_sc_mcu7t5v0__fillcap_8
X_1514_ _1526_/A1 _1921_/Q _1515_/B VDD VDD VSS VSS gf180mcu_fd_sc_mcu7t5v0__nand2_1
XFILLER_5_680 VDD VDD VSS VSS gf180mcu_fd_sc_mcu7t5v0__fillcap_4
X_1445_ _2153_/D _2152_/D _1445_/S _1891_/D VDD VDD VSS VSS gf180mcu_fd_sc_mcu7t5v0__mux2_2
X_1376_ _1376_/A1 _1376_/A2 input68/Z _1377_/A2 VDD VDD VSS VSS gf180mcu_fd_sc_mcu7t5v0__nand3_1
XFILLER_67_142 VDD VDD VSS VSS gf180mcu_fd_sc_mcu7t5v0__fillcap_8
XFILLER_82_101 VDD VDD VSS VSS gf180mcu_fd_sc_mcu7t5v0__fillcap_4
XTAP_TAPCELL_ROW_66_844 VDD VSS gf180mcu_fd_sc_mcu7t5v0__filltie
XFILLER_82_123 VDD VDD VSS VSS gf180mcu_fd_sc_mcu7t5v0__fill_2
XFILLER_23_212 VDD VDD VSS VSS gf180mcu_fd_sc_mcu7t5v0__fillcap_16
XFILLER_23_278 VDD VDD VSS VSS gf180mcu_fd_sc_mcu7t5v0__fill_2
Xwire309 wire309/I cfg_data_o[16] VDD VDD VSS VSS gf180mcu_fd_sc_mcu7t5v0__clkbuf_3
XTAP_TAPCELL_ROW_21_413 VDD VSS gf180mcu_fd_sc_mcu7t5v0__filltie
XFILLER_3_628 VDD VDD VSS VSS gf180mcu_fd_sc_mcu7t5v0__fill_2
Xfanout420 _2054_/Q _1703_/C VDD VDD VSS VSS gf180mcu_fd_sc_mcu7t5v0__dlyb_1
Xfanout431 input38/Z _1319_/B VDD VDD VSS VSS gf180mcu_fd_sc_mcu7t5v0__clkbuf_2
XFILLER_78_429 VDD VDD VSS VSS gf180mcu_fd_sc_mcu7t5v0__fill_2
XFILLER_59_632 VDD VDD VSS VSS gf180mcu_fd_sc_mcu7t5v0__fillcap_32
Xfanout453 fanout458/Z _0904_/I VDD VDD VSS VSS gf180mcu_fd_sc_mcu7t5v0__dlyb_1
Xfanout464 _2176_/RN _2139_/RN VDD VDD VSS VSS gf180mcu_fd_sc_mcu7t5v0__dlyb_1
XFILLER_74_613 VDD VDD VSS VSS gf180mcu_fd_sc_mcu7t5v0__fillcap_32
XFILLER_27_562 VDD VDD VSS VSS gf180mcu_fd_sc_mcu7t5v0__fillcap_32
XFILLER_64_99 VDD VDD VSS VSS gf180mcu_fd_sc_mcu7t5v0__fillcap_4
XFILLER_2_661 VDD VDD VSS VSS gf180mcu_fd_sc_mcu7t5v0__fillcap_4
XFILLER_2_683 VDD VDD VSS VSS gf180mcu_fd_sc_mcu7t5v0__fillcap_8
X_1230_ _1230_/A1 _1230_/A2 _1229_/Z _2140_/D VDD VDD VSS VSS gf180mcu_fd_sc_mcu7t5v0__nor3_1
X_1161_ _1161_/A1 _2055_/Q _2053_/Q _1734_/A2 VDD VDD VSS VSS gf180mcu_fd_sc_mcu7t5v0__nor3_1
XFILLER_49_142 VDD VDD VSS VSS gf180mcu_fd_sc_mcu7t5v0__fillcap_8
X_1092_ _1145_/A1 _1270_/A2 _1096_/A1 VDD VDD VSS VSS gf180mcu_fd_sc_mcu7t5v0__nand2_1
XFILLER_92_465 VDD VDD VSS VSS gf180mcu_fd_sc_mcu7t5v0__fill_1
XFILLER_92_454 VDD VDD VSS VSS gf180mcu_fd_sc_mcu7t5v0__fill_1
XFILLER_64_167 VDD VDD VSS VSS gf180mcu_fd_sc_mcu7t5v0__fillcap_8
Xclkbuf_5_9__f_periph_clk_i clkbuf_4_4_0_periph_clk_i/Z _2182_/CLK VDD VDD VSS VSS
+ gf180mcu_fd_sc_mcu7t5v0__clkbuf_16
XTAP_TAPCELL_ROW_63_814 VDD VSS gf180mcu_fd_sc_mcu7t5v0__filltie
XFILLER_52_329 VDD VDD VSS VSS gf180mcu_fd_sc_mcu7t5v0__fill_2
XTAP_TAPCELL_ROW_35_549 VDD VSS gf180mcu_fd_sc_mcu7t5v0__filltie
XFILLER_20_226 VDD VDD VSS VSS gf180mcu_fd_sc_mcu7t5v0__fillcap_4
X_1994_ _1994_/D _2117_/RN _2025_/CLK _1994_/Q VDD VDD VSS VSS gf180mcu_fd_sc_mcu7t5v0__dffrnq_1
XTAP_TAPCELL_ROW_71_891 VDD VSS gf180mcu_fd_sc_mcu7t5v0__filltie
X_0945_ _2174_/Q _1296_/A2 VDD VDD VSS VSS gf180mcu_fd_sc_mcu7t5v0__clkinv_1
XFILLER_9_282 VDD VDD VSS VSS gf180mcu_fd_sc_mcu7t5v0__fill_2
X_1428_ _1875_/Q _2059_/Q _1432_/S _1875_/D VDD VDD VSS VSS gf180mcu_fd_sc_mcu7t5v0__mux2_2
XFILLER_18_37 VDD VDD VSS VSS gf180mcu_fd_sc_mcu7t5v0__fillcap_64
X_1359_ _1977_/Q _1179_/Z _1395_/A2 input77/Z _1360_/A3 VDD VDD VSS VSS gf180mcu_fd_sc_mcu7t5v0__aoi22_1
XFILLER_28_359 VDD VDD VSS VSS gf180mcu_fd_sc_mcu7t5v0__fillcap_16
XTAP_TAPCELL_ROW_87_1035 VDD VSS gf180mcu_fd_sc_mcu7t5v0__filltie
XFILLER_83_454 VDD VDD VSS VSS gf180mcu_fd_sc_mcu7t5v0__fillcap_8
XFILLER_70_159 VDD VDD VSS VSS gf180mcu_fd_sc_mcu7t5v0__fill_2
XFILLER_24_576 VDD VDD VSS VSS gf180mcu_fd_sc_mcu7t5v0__fillcap_4
Xclkload2 clkload2/I clkload2/Z VDD VDD VSS VSS gf180mcu_fd_sc_mcu7t5v0__clkbuf_2
XTAP_TAPCELL_ROW_98_1153 VDD VSS gf180mcu_fd_sc_mcu7t5v0__filltie
XTAP_TAPCELL_ROW_98_1142 VDD VSS gf180mcu_fd_sc_mcu7t5v0__filltie
Xfanout272 _1672_/S _1587_/S VDD VDD VSS VSS gf180mcu_fd_sc_mcu7t5v0__buf_1
XTAP_TAPCELL_ROW_6_274 VDD VSS gf180mcu_fd_sc_mcu7t5v0__filltie
XFILLER_47_624 VDD VDD VSS VSS gf180mcu_fd_sc_mcu7t5v0__fillcap_4
XFILLER_74_454 VDD VDD VSS VSS gf180mcu_fd_sc_mcu7t5v0__fill_1
XFILLER_15_554 VDD VDD VSS VSS gf180mcu_fd_sc_mcu7t5v0__fill_1
XTAP_TAPCELL_ROW_32_519 VDD VSS gf180mcu_fd_sc_mcu7t5v0__filltie
XFILLER_30_535 VDD VDD VSS VSS gf180mcu_fd_sc_mcu7t5v0__fillcap_4
XFILLER_70_693 VDD VDD VSS VSS gf180mcu_fd_sc_mcu7t5v0__fill_1
XFILLER_42_384 VDD VDD VSS VSS gf180mcu_fd_sc_mcu7t5v0__fill_1
XTAP_TAPCELL_ROW_40_596 VDD VSS gf180mcu_fd_sc_mcu7t5v0__filltie
X_1213_ _2134_/Q _2135_/Q _2136_/Q _1205_/Z _1213_/Z VDD VDD VSS VSS gf180mcu_fd_sc_mcu7t5v0__and4_1
X_2193_ _2193_/D _2193_/RN _2194_/CLK _2193_/Q VDD VDD VSS VSS gf180mcu_fd_sc_mcu7t5v0__dffrnq_1
X_1144_ _1146_/A1 _2164_/Q _1303_/A1 _2100_/Q _1150_/A1 VDD VDD VSS VSS gf180mcu_fd_sc_mcu7t5v0__oai22_1
XFILLER_65_454 VDD VDD VSS VSS gf180mcu_fd_sc_mcu7t5v0__fillcap_16
X_1075_ _1075_/A1 _1075_/A2 _1075_/A3 _1075_/A4 _1081_/A1 VDD VDD VSS VSS gf180mcu_fd_sc_mcu7t5v0__nand4_1
XFILLER_65_487 VDD VDD VSS VSS gf180mcu_fd_sc_mcu7t5v0__fill_2
XFILLER_52_115 VDD VDD VSS VSS gf180mcu_fd_sc_mcu7t5v0__fillcap_4
XFILLER_52_104 VDD VDD VSS VSS gf180mcu_fd_sc_mcu7t5v0__fill_1
XFILLER_80_457 VDD VDD VSS VSS gf180mcu_fd_sc_mcu7t5v0__fillcap_16
XFILLER_33_384 VDD VDD VSS VSS gf180mcu_fd_sc_mcu7t5v0__fillcap_8
XFILLER_60_181 VDD VDD VSS VSS gf180mcu_fd_sc_mcu7t5v0__fill_2
XFILLER_21_557 VDD VDD VSS VSS gf180mcu_fd_sc_mcu7t5v0__fill_2
X_1977_ _1977_/D _2127_/RN clkload6/I _1977_/Q VDD VDD VSS VSS gf180mcu_fd_sc_mcu7t5v0__dffrnq_1
X_0928_ _2100_/Q _1127_/B1 VDD VDD VSS VSS gf180mcu_fd_sc_mcu7t5v0__clkinv_1
XTAP_TAPCELL_ROW_93_1094 VDD VSS gf180mcu_fd_sc_mcu7t5v0__filltie
XFILLER_88_535 VDD VDD VSS VSS gf180mcu_fd_sc_mcu7t5v0__fillcap_32
XFILLER_88_524 VDD VDD VSS VSS gf180mcu_fd_sc_mcu7t5v0__fill_1
XTAP_TAPCELL_ROW_3_244 VDD VSS gf180mcu_fd_sc_mcu7t5v0__filltie
XFILLER_44_605 VDD VDD VSS VSS gf180mcu_fd_sc_mcu7t5v0__fill_2
XFILLER_56_498 VDD VDD VSS VSS gf180mcu_fd_sc_mcu7t5v0__fill_1
XFILLER_45_35 VDD VDD VSS VSS gf180mcu_fd_sc_mcu7t5v0__fillcap_32
XFILLER_71_468 VDD VDD VSS VSS gf180mcu_fd_sc_mcu7t5v0__fillcap_4
XFILLER_71_435 VDD VDD VSS VSS gf180mcu_fd_sc_mcu7t5v0__fillcap_16
XFILLER_24_362 VDD VDD VSS VSS gf180mcu_fd_sc_mcu7t5v0__fillcap_4
XFILLER_12_524 VDD VDD VSS VSS gf180mcu_fd_sc_mcu7t5v0__fill_1
XFILLER_24_384 VDD VDD VSS VSS gf180mcu_fd_sc_mcu7t5v0__fill_1
XFILLER_12_579 VDD VDD VSS VSS gf180mcu_fd_sc_mcu7t5v0__fillcap_16
XFILLER_8_517 VDD VDD VSS VSS gf180mcu_fd_sc_mcu7t5v0__fillcap_8
XFILLER_61_67 VDD VDD VSS VSS gf180mcu_fd_sc_mcu7t5v0__fill_2
XPHY_EDGE_ROW_20_Left_119 VDD VSS gf180mcu_fd_sc_mcu7t5v0__endcap
XFILLER_94_527 VDD VDD VSS VSS gf180mcu_fd_sc_mcu7t5v0__fillcap_64
XFILLER_66_218 VDD VDD VSS VSS gf180mcu_fd_sc_mcu7t5v0__fill_1
XFILLER_66_229 VDD VDD VSS VSS gf180mcu_fd_sc_mcu7t5v0__fill_1
XFILLER_34_104 VDD VDD VSS VSS gf180mcu_fd_sc_mcu7t5v0__fill_1
XTAP_TAPCELL_ROW_45_644 VDD VSS gf180mcu_fd_sc_mcu7t5v0__filltie
X_1900_ _1900_/D _1951_/RN _1921_/CLK _1900_/Q VDD VDD VSS VSS gf180mcu_fd_sc_mcu7t5v0__dffrnq_1
XFILLER_96_6 VDD VDD VSS VSS gf180mcu_fd_sc_mcu7t5v0__fillcap_16
X_1831_ _2069_/Q _2071_/Q _1832_/A2 _1831_/A4 _1834_/A2 VDD VDD VSS VSS gf180mcu_fd_sc_mcu7t5v0__nand4_1
XFILLER_30_387 VDD VDD VSS VSS gf180mcu_fd_sc_mcu7t5v0__fillcap_16
X_1762_ _2071_/Q _1823_/S _1769_/B VDD VDD VSS VSS gf180mcu_fd_sc_mcu7t5v0__nand2_1
X_1693_ _1739_/A1 _2065_/Q _1696_/A1 VDD VDD VSS VSS gf180mcu_fd_sc_mcu7t5v0__nand2_1
Xhold517 _2123_/Q _2119_/D VDD VDD VSS VSS gf180mcu_fd_sc_mcu7t5v0__dlyc_1
Xload_slew442 _1959_/RN _2028_/RN VDD VDD VSS VSS gf180mcu_fd_sc_mcu7t5v0__clkbuf_3
XFILLER_97_354 VDD VDD VSS VSS gf180mcu_fd_sc_mcu7t5v0__fill_1
Xload_slew475 _1963_/RN _2092_/RN VDD VDD VSS VSS gf180mcu_fd_sc_mcu7t5v0__clkbuf_3
XFILLER_85_538 VDD VDD VSS VSS gf180mcu_fd_sc_mcu7t5v0__fill_1
X_2176_ _2176_/D _2176_/RN _2176_/CLK _2176_/Q VDD VDD VSS VSS gf180mcu_fd_sc_mcu7t5v0__dffrnq_1
XTAP_TAPCELL_ROW_0_203 VDD VSS gf180mcu_fd_sc_mcu7t5v0__filltie
XFILLER_38_454 VDD VDD VSS VSS gf180mcu_fd_sc_mcu7t5v0__fill_1
X_1127_ _1145_/A1 _2165_/Q _1127_/B1 _2175_/Q _1129_/A1 VDD VDD VSS VSS gf180mcu_fd_sc_mcu7t5v0__aoi22_1
XTAP_TAPCELL_ROW_0_214 VDD VSS gf180mcu_fd_sc_mcu7t5v0__filltie
XFILLER_53_402 VDD VDD VSS VSS gf180mcu_fd_sc_mcu7t5v0__fillcap_8
X_1058_ _2151_/D _2153_/D _2152_/D _1415_/A3 VDD VDD VSS VSS gf180mcu_fd_sc_mcu7t5v0__oai21_1
XFILLER_40_107 VDD VDD VSS VSS gf180mcu_fd_sc_mcu7t5v0__fill_1
XFILLER_33_192 VDD VDD VSS VSS gf180mcu_fd_sc_mcu7t5v0__fillcap_16
XTAP_TAPCELL_ROW_95_1112 VDD VSS gf180mcu_fd_sc_mcu7t5v0__filltie
XPHY_EDGE_ROW_1_Right_1 VDD VSS gf180mcu_fd_sc_mcu7t5v0__endcap
Xinput104 data_tx_i[2] _1571_/I0 VDD VDD VSS VSS gf180mcu_fd_sc_mcu7t5v0__dlyb_1
XFILLER_76_527 VDD VDD VSS VSS gf180mcu_fd_sc_mcu7t5v0__fill_2
XTAP_TAPCELL_ROW_59_769 VDD VSS gf180mcu_fd_sc_mcu7t5v0__filltie
XFILLER_56_45 VDD VDD VSS VSS gf180mcu_fd_sc_mcu7t5v0__fill_2
XFILLER_16_115 VDD VDD VSS VSS gf180mcu_fd_sc_mcu7t5v0__fillcap_4
XFILLER_84_593 VDD VDD VSS VSS gf180mcu_fd_sc_mcu7t5v0__fill_2
XFILLER_44_457 VDD VDD VSS VSS gf180mcu_fd_sc_mcu7t5v0__fillcap_16
XFILLER_71_254 VDD VDD VSS VSS gf180mcu_fd_sc_mcu7t5v0__fillcap_16
XTAP_TAPCELL_ROW_42_614 VDD VSS gf180mcu_fd_sc_mcu7t5v0__filltie
XFILLER_71_298 VDD VDD VSS VSS gf180mcu_fd_sc_mcu7t5v0__fill_2
XTAP_TAPCELL_ROW_14_349 VDD VSS gf180mcu_fd_sc_mcu7t5v0__filltie
XFILLER_12_387 VDD VDD VSS VSS gf180mcu_fd_sc_mcu7t5v0__fillcap_8
XFILLER_8_314 VDD VDD VSS VSS gf180mcu_fd_sc_mcu7t5v0__fill_1
XTAP_TAPCELL_ROW_50_691 VDD VSS gf180mcu_fd_sc_mcu7t5v0__filltie
Xudma_uart_top_498 data_rx_o[22] VDD VDD VSS VSS gf180mcu_fd_sc_mcu7t5v0__tiel
Xudma_uart_top_487 data_rx_o[11] VDD VDD VSS VSS gf180mcu_fd_sc_mcu7t5v0__tiel
XFILLER_4_597 VDD VDD VSS VSS gf180mcu_fd_sc_mcu7t5v0__fillcap_64
XFILLER_94_313 VDD VDD VSS VSS gf180mcu_fd_sc_mcu7t5v0__fill_2
X_2030_ _2030_/D _2033_/RN clkload0/I _2030_/Q VDD VDD VSS VSS gf180mcu_fd_sc_mcu7t5v0__dffrnq_1
XFILLER_94_357 VDD VDD VSS VSS gf180mcu_fd_sc_mcu7t5v0__fillcap_16
XFILLER_47_262 VDD VDD VSS VSS gf180mcu_fd_sc_mcu7t5v0__fill_2
XFILLER_22_107 VDD VDD VSS VSS gf180mcu_fd_sc_mcu7t5v0__fillcap_64
XFILLER_23_619 VDD VDD VSS VSS gf180mcu_fd_sc_mcu7t5v0__fillcap_4
XFILLER_16_671 VDD VDD VSS VSS gf180mcu_fd_sc_mcu7t5v0__fill_1
XFILLER_87_2 VDD VDD VSS VSS gf180mcu_fd_sc_mcu7t5v0__fillcap_64
X_1814_ _1815_/C _1814_/A2 _1814_/A3 _1816_/A2 VDD VDD VSS VSS gf180mcu_fd_sc_mcu7t5v0__nand3_1
X_1745_ _2070_/Q _2083_/Q _1746_/B _1755_/A2 VDD VDD VSS VSS gf180mcu_fd_sc_mcu7t5v0__nand3_1
XFILLER_7_72 VDD VDD VSS VSS gf180mcu_fd_sc_mcu7t5v0__fillcap_8
X_1676_ _1449_/B _1686_/A2 _1678_/S VDD VDD VSS VSS gf180mcu_fd_sc_mcu7t5v0__nor2_1
XTAP_TAPCELL_ROW_90_1064 VDD VSS gf180mcu_fd_sc_mcu7t5v0__filltie
Xload_slew261 _1652_/S _1664_/S VDD VDD VSS VSS gf180mcu_fd_sc_mcu7t5v0__buf_4
XFILLER_58_527 VDD VDD VSS VSS gf180mcu_fd_sc_mcu7t5v0__fillcap_8
XFILLER_73_508 VDD VDD VSS VSS gf180mcu_fd_sc_mcu7t5v0__fillcap_8
XFILLER_26_37 VDD VDD VSS VSS gf180mcu_fd_sc_mcu7t5v0__fill_1
XFILLER_26_48 VDD VDD VSS VSS gf180mcu_fd_sc_mcu7t5v0__fillcap_32
X_2159_ _2159_/D _2081_/RN clkload9/I _2159_/Q VDD VDD VSS VSS gf180mcu_fd_sc_mcu7t5v0__dffsnq_1
XFILLER_26_457 VDD VDD VSS VSS gf180mcu_fd_sc_mcu7t5v0__fillcap_32
XFILLER_81_574 VDD VDD VSS VSS gf180mcu_fd_sc_mcu7t5v0__fill_1
XFILLER_53_298 VDD VDD VSS VSS gf180mcu_fd_sc_mcu7t5v0__fillcap_32
XFILLER_41_416 VDD VDD VSS VSS gf180mcu_fd_sc_mcu7t5v0__fillcap_4
XTAP_TAPCELL_ROW_11_319 VDD VSS gf180mcu_fd_sc_mcu7t5v0__filltie
XFILLER_1_556 VDD VDD VSS VSS gf180mcu_fd_sc_mcu7t5v0__fillcap_4
XFILLER_67_44 VDD VDD VSS VSS gf180mcu_fd_sc_mcu7t5v0__fill_2
XFILLER_29_262 VDD VDD VSS VSS gf180mcu_fd_sc_mcu7t5v0__fill_1
XFILLER_17_446 VDD VDD VSS VSS gf180mcu_fd_sc_mcu7t5v0__fillcap_4
XFILLER_44_232 VDD VDD VSS VSS gf180mcu_fd_sc_mcu7t5v0__fill_1
XFILLER_44_243 VDD VDD VSS VSS gf180mcu_fd_sc_mcu7t5v0__fill_2
X_1530_ _2124_/D _2123_/D _1531_/S _1930_/D VDD VDD VSS VSS gf180mcu_fd_sc_mcu7t5v0__mux2_2
X_1461_ _1460_/Z _1897_/Q _1473_/S _1897_/D VDD VDD VSS VSS gf180mcu_fd_sc_mcu7t5v0__mux2_2
XFILLER_4_372 VDD VDD VSS VSS gf180mcu_fd_sc_mcu7t5v0__fillcap_8
X_1392_ input70/Z _1395_/A2 _1392_/B1 input86/Z _1394_/A1 VDD VDD VSS VSS gf180mcu_fd_sc_mcu7t5v0__aoi22_1
XFILLER_67_346 VDD VDD VSS VSS gf180mcu_fd_sc_mcu7t5v0__fillcap_4
XFILLER_55_508 VDD VDD VSS VSS gf180mcu_fd_sc_mcu7t5v0__fill_2
XFILLER_95_688 VDD VDD VSS VSS gf180mcu_fd_sc_mcu7t5v0__fillcap_4
X_2013_ _2013_/D _2025_/RN _2024_/CLK _2013_/Q VDD VDD VSS VSS gf180mcu_fd_sc_mcu7t5v0__dffrnq_1
XFILLER_63_552 VDD VDD VSS VSS gf180mcu_fd_sc_mcu7t5v0__fillcap_8
XFILLER_23_416 VDD VDD VSS VSS gf180mcu_fd_sc_mcu7t5v0__fillcap_4
XFILLER_35_298 VDD VDD VSS VSS gf180mcu_fd_sc_mcu7t5v0__fillcap_8
X_1728_ _1728_/A1 _1732_/A3 _2160_/Q _1734_/A2 _1728_/Z VDD VDD VSS VSS gf180mcu_fd_sc_mcu7t5v0__and4_1
X_1659_ _2029_/Q input7/Z _1664_/S _2029_/D VDD VDD VSS VSS gf180mcu_fd_sc_mcu7t5v0__mux2_2
XTAP_TAPCELL_ROW_69_864 VDD VSS gf180mcu_fd_sc_mcu7t5v0__filltie
XFILLER_26_210 VDD VDD VSS VSS gf180mcu_fd_sc_mcu7t5v0__fill_1
XFILLER_37_69 VDD VDD VSS VSS gf180mcu_fd_sc_mcu7t5v0__fill_1
XFILLER_73_338 VDD VDD VSS VSS gf180mcu_fd_sc_mcu7t5v0__fillcap_8
XTAP_TAPCELL_ROW_24_444 VDD VSS gf180mcu_fd_sc_mcu7t5v0__filltie
XFILLER_53_68 VDD VDD VSS VSS gf180mcu_fd_sc_mcu7t5v0__fill_2
XFILLER_41_279 VDD VDD VSS VSS gf180mcu_fd_sc_mcu7t5v0__fill_1
XFILLER_77_666 VDD VDD VSS VSS gf180mcu_fd_sc_mcu7t5v0__fillcap_16
XFILLER_49_368 VDD VDD VSS VSS gf180mcu_fd_sc_mcu7t5v0__fillcap_4
XFILLER_17_243 VDD VDD VSS VSS gf180mcu_fd_sc_mcu7t5v0__fill_1
XFILLER_32_202 VDD VDD VSS VSS gf180mcu_fd_sc_mcu7t5v0__fillcap_32
XFILLER_72_382 VDD VDD VSS VSS gf180mcu_fd_sc_mcu7t5v0__fill_2
X_0961_ _0961_/A1 _2185_/Q _1669_/A1 VDD VDD VSS VSS gf180mcu_fd_sc_mcu7t5v0__nand2_1
Xoutput216 _1557_/A1 wire285/I VDD VDD VSS VSS gf180mcu_fd_sc_mcu7t5v0__buf_1
Xoutput205 _2015_/Q wire355/I VDD VDD VSS VSS gf180mcu_fd_sc_mcu7t5v0__buf_1
X_1513_ _1513_/A1 _1513_/A2 _1920_/D VDD VDD VSS VSS gf180mcu_fd_sc_mcu7t5v0__nand2_1
X_1444_ _2152_/D _2151_/D _1444_/S _1890_/D VDD VDD VSS VSS gf180mcu_fd_sc_mcu7t5v0__mux2_2
X_1375_ input80/Z _1395_/A2 _1392_/B1 input92/Z _1379_/A2 VDD VDD VSS VSS gf180mcu_fd_sc_mcu7t5v0__aoi22_1
XTAP_TAPCELL_ROW_38_569 VDD VSS gf180mcu_fd_sc_mcu7t5v0__filltie
XFILLER_82_168 VDD VDD VSS VSS gf180mcu_fd_sc_mcu7t5v0__fillcap_4
XFILLER_91_680 VDD VDD VSS VSS gf180mcu_fd_sc_mcu7t5v0__fillcap_8
XFILLER_63_360 VDD VDD VSS VSS gf180mcu_fd_sc_mcu7t5v0__fillcap_4
XFILLER_51_577 VDD VDD VSS VSS gf180mcu_fd_sc_mcu7t5v0__fillcap_16
XTAP_TAPCELL_ROW_21_414 VDD VSS gf180mcu_fd_sc_mcu7t5v0__filltie
Xfanout432 input3/Z _0906_/I VDD VDD VSS VSS gf180mcu_fd_sc_mcu7t5v0__dlya_1
Xfanout443 fanout458/Z _2020_/RN VDD VDD VSS VSS gf180mcu_fd_sc_mcu7t5v0__dlyb_1
Xfanout454 _2185_/RN _2194_/RN VDD VDD VSS VSS gf180mcu_fd_sc_mcu7t5v0__buf_1
Xfanout465 _1926_/RN _1923_/RN VDD VDD VSS VSS gf180mcu_fd_sc_mcu7t5v0__dlyb_1
Xfanout476 _2174_/RN _2098_/RN VDD VDD VSS VSS gf180mcu_fd_sc_mcu7t5v0__buf_1
XFILLER_59_688 VDD VDD VSS VSS gf180mcu_fd_sc_mcu7t5v0__fillcap_4
XFILLER_73_146 VDD VDD VSS VSS gf180mcu_fd_sc_mcu7t5v0__fill_2
XFILLER_64_45 VDD VDD VSS VSS gf180mcu_fd_sc_mcu7t5v0__fillcap_4
XFILLER_82_691 VDD VDD VSS VSS gf180mcu_fd_sc_mcu7t5v0__fill_2
XFILLER_42_588 VDD VDD VSS VSS gf180mcu_fd_sc_mcu7t5v0__fillcap_4
XFILLER_10_485 VDD VDD VSS VSS gf180mcu_fd_sc_mcu7t5v0__fillcap_32
XFILLER_6_445 VDD VDD VSS VSS gf180mcu_fd_sc_mcu7t5v0__fill_2
XTAP_TAPCELL_ROW_9_294 VDD VSS gf180mcu_fd_sc_mcu7t5v0__filltie
XFILLER_69_419 VDD VDD VSS VSS gf180mcu_fd_sc_mcu7t5v0__fill_1
X_1160_ _1161_/A1 _1691_/C _1733_/A2 VDD VDD VSS VSS gf180mcu_fd_sc_mcu7t5v0__nor2_1
XFILLER_49_154 VDD VDD VSS VSS gf180mcu_fd_sc_mcu7t5v0__fill_2
XFILLER_49_187 VDD VDD VSS VSS gf180mcu_fd_sc_mcu7t5v0__fillcap_8
Xclkbuf_4_4_0_periph_clk_i clkbuf_0_periph_clk_i/Z clkbuf_4_4_0_periph_clk_i/Z VDD
+ VDD VSS VSS gf180mcu_fd_sc_mcu7t5v0__clkbuf_2
X_1091_ _1091_/A1 _1091_/A2 _1089_/Z _1091_/B2 _1108_/A1 VDD VDD VSS VSS gf180mcu_fd_sc_mcu7t5v0__aoi22_1
XTAP_TAPCELL_ROW_63_815 VDD VSS gf180mcu_fd_sc_mcu7t5v0__filltie
XFILLER_73_680 VDD VDD VSS VSS gf180mcu_fd_sc_mcu7t5v0__fillcap_8
XFILLER_45_371 VDD VDD VSS VSS gf180mcu_fd_sc_mcu7t5v0__fill_2
X_1993_ _1993_/D _2127_/RN _2020_/CLK _1993_/Q VDD VDD VSS VSS gf180mcu_fd_sc_mcu7t5v0__dffrnq_1
X_0944_ _2173_/Q _1296_/A1 VDD VDD VSS VSS gf180mcu_fd_sc_mcu7t5v0__clkinv_1
Xclkload20 _2176_/CLK clkload20/Z VDD VDD VSS VSS gf180mcu_fd_sc_mcu7t5v0__clkbuf_2
X_1427_ _1874_/Q _2058_/Q _1432_/S _1874_/D VDD VDD VSS VSS gf180mcu_fd_sc_mcu7t5v0__mux2_2
XFILLER_18_16 VDD VDD VSS VSS gf180mcu_fd_sc_mcu7t5v0__fillcap_16
X_1358_ input47/Z _1396_/A2 _1393_/B1 input59/Z _1360_/A2 VDD VDD VSS VSS gf180mcu_fd_sc_mcu7t5v0__aoi22_1
XFILLER_95_282 VDD VDD VSS VSS gf180mcu_fd_sc_mcu7t5v0__fillcap_4
XFILLER_83_422 VDD VDD VSS VSS gf180mcu_fd_sc_mcu7t5v0__fillcap_32
XFILLER_55_124 VDD VDD VSS VSS gf180mcu_fd_sc_mcu7t5v0__fill_2
X_1289_ _2168_/Q _1289_/A2 _1288_/Z _1292_/A2 VDD VDD VSS VSS gf180mcu_fd_sc_mcu7t5v0__nand3_1
XTAP_TAPCELL_ROW_87_1036 VDD VSS gf180mcu_fd_sc_mcu7t5v0__filltie
XFILLER_55_146 VDD VDD VSS VSS gf180mcu_fd_sc_mcu7t5v0__fill_1
XFILLER_71_628 VDD VDD VSS VSS gf180mcu_fd_sc_mcu7t5v0__fill_2
XFILLER_55_168 VDD VDD VSS VSS gf180mcu_fd_sc_mcu7t5v0__fill_2
XFILLER_24_533 VDD VDD VSS VSS gf180mcu_fd_sc_mcu7t5v0__fillcap_8
XFILLER_34_37 VDD VDD VSS VSS gf180mcu_fd_sc_mcu7t5v0__fillcap_8
XFILLER_36_393 VDD VDD VSS VSS gf180mcu_fd_sc_mcu7t5v0__fillcap_16
XFILLER_70_149 VDD VDD VSS VSS gf180mcu_fd_sc_mcu7t5v0__fill_1
XFILLER_64_691 VDD VDD VSS VSS gf180mcu_fd_sc_mcu7t5v0__fill_2
XFILLER_63_190 VDD VDD VSS VSS gf180mcu_fd_sc_mcu7t5v0__fillcap_8
XFILLER_51_352 VDD VDD VSS VSS gf180mcu_fd_sc_mcu7t5v0__fillcap_8
XFILLER_51_341 VDD VDD VSS VSS gf180mcu_fd_sc_mcu7t5v0__fillcap_8
Xclkload3 clkload3/I clkload3/Z VDD VDD VSS VSS gf180mcu_fd_sc_mcu7t5v0__clkbuf_2
XTAP_TAPCELL_ROW_98_1154 VDD VSS gf180mcu_fd_sc_mcu7t5v0__filltie
XTAP_TAPCELL_ROW_98_1143 VDD VSS gf180mcu_fd_sc_mcu7t5v0__filltie
XFILLER_3_426 VDD VDD VSS VSS gf180mcu_fd_sc_mcu7t5v0__fill_2
XFILLER_78_238 VDD VDD VSS VSS gf180mcu_fd_sc_mcu7t5v0__fillcap_4
XFILLER_59_78 VDD VDD VSS VSS gf180mcu_fd_sc_mcu7t5v0__fill_1
Xfanout262 _1648_/ZN _1653_/S VDD VDD VSS VSS gf180mcu_fd_sc_mcu7t5v0__buf_1
Xfanout273 _1583_/ZN _1603_/S VDD VDD VSS VSS gf180mcu_fd_sc_mcu7t5v0__dlyb_1
XFILLER_47_636 VDD VDD VSS VSS gf180mcu_fd_sc_mcu7t5v0__fill_2
XFILLER_55_680 VDD VDD VSS VSS gf180mcu_fd_sc_mcu7t5v0__fillcap_8
XFILLER_15_588 VDD VDD VSS VSS gf180mcu_fd_sc_mcu7t5v0__fill_1
XFILLER_70_683 VDD VDD VSS VSS gf180mcu_fd_sc_mcu7t5v0__fillcap_8
XFILLER_42_374 VDD VDD VSS VSS gf180mcu_fd_sc_mcu7t5v0__fillcap_8
XTAP_TAPCELL_ROW_40_597 VDD VSS gf180mcu_fd_sc_mcu7t5v0__filltie
XFILLER_97_558 VDD VDD VSS VSS gf180mcu_fd_sc_mcu7t5v0__fill_2
X_1212_ _1230_/A1 _1212_/A2 _1211_/Z _2135_/D VDD VDD VSS VSS gf180mcu_fd_sc_mcu7t5v0__nor3_1
X_2192_ _2192_/D _2193_/RN _2194_/CLK _2192_/Q VDD VDD VSS VSS gf180mcu_fd_sc_mcu7t5v0__dffrnq_1
XFILLER_65_422 VDD VDD VSS VSS gf180mcu_fd_sc_mcu7t5v0__fillcap_32
XFILLER_65_400 VDD VDD VSS VSS gf180mcu_fd_sc_mcu7t5v0__fillcap_16
XFILLER_37_157 VDD VDD VSS VSS gf180mcu_fd_sc_mcu7t5v0__fillcap_8
X_1143_ _1143_/A1 _1143_/A2 _1142_/Z _1290_/A2 VDD VDD VSS VSS gf180mcu_fd_sc_mcu7t5v0__nand3_1
XFILLER_92_241 VDD VDD VSS VSS gf180mcu_fd_sc_mcu7t5v0__fillcap_4
XFILLER_77_293 VDD VDD VSS VSS gf180mcu_fd_sc_mcu7t5v0__fillcap_8
X_1074_ _1146_/A1 _2165_/Q _1127_/B1 _2176_/Q _1075_/A4 VDD VDD VSS VSS gf180mcu_fd_sc_mcu7t5v0__aoi22_1
XTAP_TAPCELL_ROW_48_664 VDD VSS gf180mcu_fd_sc_mcu7t5v0__filltie
XFILLER_80_403 VDD VDD VSS VSS gf180mcu_fd_sc_mcu7t5v0__fill_1
XFILLER_53_628 VDD VDD VSS VSS gf180mcu_fd_sc_mcu7t5v0__fill_2
XFILLER_33_352 VDD VDD VSS VSS gf180mcu_fd_sc_mcu7t5v0__fillcap_32
X_1976_ _1976_/D _2193_/RN _2189_/CLK _1976_/Q VDD VDD VSS VSS gf180mcu_fd_sc_mcu7t5v0__dffrnq_1
X_0927_ _2098_/Q _1141_/B2 VDD VDD VSS VSS gf180mcu_fd_sc_mcu7t5v0__clkinv_1
XFILLER_0_429 VDD VDD VSS VSS gf180mcu_fd_sc_mcu7t5v0__fillcap_4
XTAP_TAPCELL_ROW_93_1095 VDD VSS gf180mcu_fd_sc_mcu7t5v0__filltie
XFILLER_96_591 VDD VDD VSS VSS gf180mcu_fd_sc_mcu7t5v0__fillcap_4
XTAP_TAPCELL_ROW_3_245 VDD VSS gf180mcu_fd_sc_mcu7t5v0__filltie
XFILLER_45_69 VDD VDD VSS VSS gf180mcu_fd_sc_mcu7t5v0__fill_1
XTAP_TAPCELL_ROW_82_987 VDD VSS gf180mcu_fd_sc_mcu7t5v0__filltie
XFILLER_3_212 VDD VDD VSS VSS gf180mcu_fd_sc_mcu7t5v0__fill_2
XFILLER_79_525 VDD VDD VSS VSS gf180mcu_fd_sc_mcu7t5v0__fillcap_4
XFILLER_79_558 VDD VDD VSS VSS gf180mcu_fd_sc_mcu7t5v0__fill_2
XFILLER_59_282 VDD VDD VSS VSS gf180mcu_fd_sc_mcu7t5v0__fillcap_16
XFILLER_47_422 VDD VDD VSS VSS gf180mcu_fd_sc_mcu7t5v0__fillcap_16
XFILLER_35_606 VDD VDD VSS VSS gf180mcu_fd_sc_mcu7t5v0__fill_2
XTAP_TAPCELL_ROW_73_910 VDD VSS gf180mcu_fd_sc_mcu7t5v0__filltie
XFILLER_74_263 VDD VDD VSS VSS gf180mcu_fd_sc_mcu7t5v0__fillcap_8
XFILLER_47_488 VDD VDD VSS VSS gf180mcu_fd_sc_mcu7t5v0__fill_2
XFILLER_15_330 VDD VDD VSS VSS gf180mcu_fd_sc_mcu7t5v0__fillcap_8
XFILLER_15_352 VDD VDD VSS VSS gf180mcu_fd_sc_mcu7t5v0__fill_1
XFILLER_15_396 VDD VDD VSS VSS gf180mcu_fd_sc_mcu7t5v0__fill_1
XFILLER_30_311 VDD VDD VSS VSS gf180mcu_fd_sc_mcu7t5v0__fillcap_4
XFILLER_42_171 VDD VDD VSS VSS gf180mcu_fd_sc_mcu7t5v0__fillcap_4
X_1830_ _1830_/A1 _1830_/A2 _1830_/A3 _1828_/B _1739_/B _2081_/D VDD VDD VSS VSS gf180mcu_fd_sc_mcu7t5v0__oai32_1
XFILLER_42_193 VDD VDD VSS VSS gf180mcu_fd_sc_mcu7t5v0__fill_2
X_1761_ _1822_/B _1760_/Z _1823_/S VDD VDD VSS VSS gf180mcu_fd_sc_mcu7t5v0__nor2_1
X_1692_ _1163_/B _1163_/C _2160_/Q _1697_/C VDD VDD VSS VSS gf180mcu_fd_sc_mcu7t5v0__aoi21_1
Xhold518 _2184_/Q _2185_/D VDD VDD VSS VSS gf180mcu_fd_sc_mcu7t5v0__dlyc_1
XFILLER_7_562 VDD VDD VSS VSS gf180mcu_fd_sc_mcu7t5v0__fillcap_4
XFILLER_78_591 VDD VDD VSS VSS gf180mcu_fd_sc_mcu7t5v0__fillcap_4
X_2175_ _2175_/D _2176_/RN _2176_/CLK _2175_/Q VDD VDD VSS VSS gf180mcu_fd_sc_mcu7t5v0__dffrnq_1
XFILLER_26_617 VDD VDD VSS VSS gf180mcu_fd_sc_mcu7t5v0__fill_2
X_1126_ _1157_/A1 _1114_/Z _1157_/C1 _1124_/Z _1126_/C _1130_/A2 VDD VDD VSS VSS gf180mcu_fd_sc_mcu7t5v0__oai221_1
XTAP_TAPCELL_ROW_84_1006 VDD VSS gf180mcu_fd_sc_mcu7t5v0__filltie
XTAP_TAPCELL_ROW_0_215 VDD VSS gf180mcu_fd_sc_mcu7t5v0__filltie
XTAP_TAPCELL_ROW_0_204 VDD VSS gf180mcu_fd_sc_mcu7t5v0__filltie
XFILLER_38_499 VDD VDD VSS VSS gf180mcu_fd_sc_mcu7t5v0__fill_2
XFILLER_15_39 VDD VDD VSS VSS gf180mcu_fd_sc_mcu7t5v0__fillcap_16
X_1057_ _1424_/A1 _1311_/S0 _1057_/B1 _1057_/B2 _1406_/A2 _1311_/S1 _1062_/A1 VDD
+ VDD VSS VSS gf180mcu_fd_sc_mcu7t5v0__oai222_1
X_1959_ _1959_/D _1959_/RN _2191_/CLK _1959_/Q VDD VDD VSS VSS gf180mcu_fd_sc_mcu7t5v0__dffrnq_1
XTAP_TAPCELL_ROW_95_1113 VDD VSS gf180mcu_fd_sc_mcu7t5v0__filltie
XFILLER_88_333 VDD VDD VSS VSS gf180mcu_fd_sc_mcu7t5v0__fillcap_8
Xinput105 data_tx_i[3] _1572_/I0 VDD VDD VSS VSS gf180mcu_fd_sc_mcu7t5v0__dlyb_1
XFILLER_29_422 VDD VDD VSS VSS gf180mcu_fd_sc_mcu7t5v0__fillcap_4
XFILLER_29_477 VDD VDD VSS VSS gf180mcu_fd_sc_mcu7t5v0__fill_1
XFILLER_56_263 VDD VDD VSS VSS gf180mcu_fd_sc_mcu7t5v0__fillcap_4
XFILLER_44_425 VDD VDD VSS VSS gf180mcu_fd_sc_mcu7t5v0__fillcap_8
XFILLER_24_171 VDD VDD VSS VSS gf180mcu_fd_sc_mcu7t5v0__fillcap_4
XTAP_TAPCELL_ROW_42_615 VDD VSS gf180mcu_fd_sc_mcu7t5v0__filltie
XFILLER_72_45 VDD VDD VSS VSS gf180mcu_fd_sc_mcu7t5v0__fill_2
XFILLER_12_333 VDD VDD VSS VSS gf180mcu_fd_sc_mcu7t5v0__fillcap_8
XFILLER_12_399 VDD VDD VSS VSS gf180mcu_fd_sc_mcu7t5v0__fill_1
XTAP_TAPCELL_ROW_50_692 VDD VSS gf180mcu_fd_sc_mcu7t5v0__filltie
XFILLER_4_510 VDD VDD VSS VSS gf180mcu_fd_sc_mcu7t5v0__fillcap_8
Xudma_uart_top_499 data_rx_o[23] VDD VDD VSS VSS gf180mcu_fd_sc_mcu7t5v0__tiel
Xudma_uart_top_488 data_rx_o[12] VDD VDD VSS VSS gf180mcu_fd_sc_mcu7t5v0__tiel
XFILLER_4_543 VDD VDD VSS VSS gf180mcu_fd_sc_mcu7t5v0__fillcap_4
XFILLER_16_661 VDD VDD VSS VSS gf180mcu_fd_sc_mcu7t5v0__fillcap_4
XFILLER_90_597 VDD VDD VSS VSS gf180mcu_fd_sc_mcu7t5v0__fillcap_64
XFILLER_30_174 VDD VDD VSS VSS gf180mcu_fd_sc_mcu7t5v0__fill_1
XFILLER_30_185 VDD VDD VSS VSS gf180mcu_fd_sc_mcu7t5v0__fill_2
X_1813_ _1813_/A1 _1815_/B2 _1918_/Q _1814_/A3 VDD VDD VSS VSS gf180mcu_fd_sc_mcu7t5v0__nand3_1
X_1744_ _1756_/A1 _2084_/Q _1831_/A4 _1747_/A2 VDD VDD VSS VSS gf180mcu_fd_sc_mcu7t5v0__nand3_1
Xwire290 wire290/I data_rx_o[3] VDD VDD VSS VSS gf180mcu_fd_sc_mcu7t5v0__clkbuf_3
X_1675_ input6/Z _2042_/Q _1675_/S _2042_/D VDD VDD VSS VSS gf180mcu_fd_sc_mcu7t5v0__mux2_2
XPHY_EDGE_ROW_15_Right_15 VDD VSS gf180mcu_fd_sc_mcu7t5v0__endcap
XTAP_TAPCELL_ROW_90_1065 VDD VSS gf180mcu_fd_sc_mcu7t5v0__filltie
Xload_slew251 _1561_/S _1568_/S VDD VDD VSS VSS gf180mcu_fd_sc_mcu7t5v0__buf_2
XFILLER_58_539 VDD VDD VSS VSS gf180mcu_fd_sc_mcu7t5v0__fill_1
XFILLER_38_263 VDD VDD VSS VSS gf180mcu_fd_sc_mcu7t5v0__fill_2
XFILLER_26_425 VDD VDD VSS VSS gf180mcu_fd_sc_mcu7t5v0__fill_2
X_2158_ _2158_/D _2081_/RN _2158_/CLK _2158_/Q VDD VDD VSS VSS gf180mcu_fd_sc_mcu7t5v0__dffsnq_1
XFILLER_66_594 VDD VDD VSS VSS gf180mcu_fd_sc_mcu7t5v0__fill_1
X_2089_ _2089_/D _2130_/RN _2130_/CLK _2089_/Q VDD VDD VSS VSS gf180mcu_fd_sc_mcu7t5v0__dffrnq_1
X_1109_ _1159_/A3 _1109_/A2 _1251_/A2 VDD VDD VSS VSS gf180mcu_fd_sc_mcu7t5v0__nor2_1
XPHY_EDGE_ROW_24_Right_24 VDD VSS gf180mcu_fd_sc_mcu7t5v0__endcap
XFILLER_53_277 VDD VDD VSS VSS gf180mcu_fd_sc_mcu7t5v0__fill_2
XFILLER_42_37 VDD VDD VSS VSS gf180mcu_fd_sc_mcu7t5v0__fillcap_4
XFILLER_5_307 VDD VDD VSS VSS gf180mcu_fd_sc_mcu7t5v0__fill_2
XPHY_EDGE_ROW_33_Right_33 VDD VSS gf180mcu_fd_sc_mcu7t5v0__endcap
XFILLER_89_664 VDD VDD VSS VSS gf180mcu_fd_sc_mcu7t5v0__fillcap_16
XPHY_EDGE_ROW_42_Right_42 VDD VSS gf180mcu_fd_sc_mcu7t5v0__endcap
XFILLER_83_66 VDD VDD VSS VSS gf180mcu_fd_sc_mcu7t5v0__fillcap_4
XFILLER_72_564 VDD VDD VSS VSS gf180mcu_fd_sc_mcu7t5v0__fillcap_16
XFILLER_44_255 VDD VDD VSS VSS gf180mcu_fd_sc_mcu7t5v0__fillcap_4
XFILLER_72_597 VDD VDD VSS VSS gf180mcu_fd_sc_mcu7t5v0__fillcap_8
XFILLER_13_664 VDD VDD VSS VSS gf180mcu_fd_sc_mcu7t5v0__fillcap_16
XFILLER_12_185 VDD VDD VSS VSS gf180mcu_fd_sc_mcu7t5v0__fillcap_4
XFILLER_32_81 VDD VDD VSS VSS gf180mcu_fd_sc_mcu7t5v0__fill_2
XPHY_EDGE_ROW_51_Right_51 VDD VSS gf180mcu_fd_sc_mcu7t5v0__endcap
X_1460_ _1941_/Q _1949_/Q _1939_/Q _1460_/Z VDD VDD VSS VSS gf180mcu_fd_sc_mcu7t5v0__mux2_2
XFILLER_4_384 VDD VDD VSS VSS gf180mcu_fd_sc_mcu7t5v0__fill_1
X_1391_ _1391_/A1 _1391_/A2 _1391_/ZN VDD VDD VSS VSS gf180mcu_fd_sc_mcu7t5v0__nand2_1
XPHY_EDGE_ROW_60_Right_60 VDD VSS gf180mcu_fd_sc_mcu7t5v0__endcap
XFILLER_94_177 VDD VDD VSS VSS gf180mcu_fd_sc_mcu7t5v0__fillcap_64
X_2012_ _2012_/D _2117_/RN _2024_/CLK _2012_/Q VDD VDD VSS VSS gf180mcu_fd_sc_mcu7t5v0__dffrnq_1
XFILLER_48_594 VDD VDD VSS VSS gf180mcu_fd_sc_mcu7t5v0__fill_1
XFILLER_35_255 VDD VDD VSS VSS gf180mcu_fd_sc_mcu7t5v0__fillcap_16
XFILLER_50_247 VDD VDD VSS VSS gf180mcu_fd_sc_mcu7t5v0__fillcap_8
X_1727_ _2064_/Q _2065_/Q _1732_/A3 VDD VDD VSS VSS gf180mcu_fd_sc_mcu7t5v0__nand2_1
X_1658_ _2028_/Q input37/Z _1662_/S _2028_/D VDD VDD VSS VSS gf180mcu_fd_sc_mcu7t5v0__mux2_2
X_1589_ _1963_/Q input16/Z _1600_/S _1963_/D VDD VDD VSS VSS gf180mcu_fd_sc_mcu7t5v0__mux2_2
XFILLER_58_303 VDD VDD VSS VSS gf180mcu_fd_sc_mcu7t5v0__fillcap_8
XFILLER_86_667 VDD VDD VSS VSS gf180mcu_fd_sc_mcu7t5v0__fillcap_16
XTAP_TAPCELL_ROW_69_865 VDD VSS gf180mcu_fd_sc_mcu7t5v0__filltie
XFILLER_66_380 VDD VDD VSS VSS gf180mcu_fd_sc_mcu7t5v0__fillcap_4
XFILLER_39_594 VDD VDD VSS VSS gf180mcu_fd_sc_mcu7t5v0__fillcap_8
Xclkbuf_5_4__f_periph_clk_i clkbuf_4_2_0_periph_clk_i/Z _2194_/CLK VDD VDD VSS VSS
+ gf180mcu_fd_sc_mcu7t5v0__clkbuf_16
XTAP_TAPCELL_ROW_52_710 VDD VSS gf180mcu_fd_sc_mcu7t5v0__filltie
XFILLER_54_597 VDD VDD VSS VSS gf180mcu_fd_sc_mcu7t5v0__fillcap_4
XFILLER_54_575 VDD VDD VSS VSS gf180mcu_fd_sc_mcu7t5v0__fillcap_4
XTAP_TAPCELL_ROW_24_445 VDD VSS gf180mcu_fd_sc_mcu7t5v0__filltie
XFILLER_41_269 VDD VDD VSS VSS gf180mcu_fd_sc_mcu7t5v0__fillcap_8
XFILLER_10_645 VDD VDD VSS VSS gf180mcu_fd_sc_mcu7t5v0__fillcap_16
XFILLER_10_667 VDD VDD VSS VSS gf180mcu_fd_sc_mcu7t5v0__fillcap_16
XFILLER_64_317 VDD VDD VSS VSS gf180mcu_fd_sc_mcu7t5v0__fillcap_8
XFILLER_91_136 VDD VDD VSS VSS gf180mcu_fd_sc_mcu7t5v0__fillcap_4
XFILLER_76_177 VDD VDD VSS VSS gf180mcu_fd_sc_mcu7t5v0__fillcap_16
XFILLER_17_222 VDD VDD VSS VSS gf180mcu_fd_sc_mcu7t5v0__fill_1
Xclkbuf_4_12_0_periph_clk_i clkbuf_0_periph_clk_i/Z clkbuf_4_12_0_periph_clk_i/Z VDD
+ VDD VSS VSS gf180mcu_fd_sc_mcu7t5v0__clkbuf_2
XFILLER_27_92 VDD VDD VSS VSS gf180mcu_fd_sc_mcu7t5v0__fillcap_4
XFILLER_72_361 VDD VDD VSS VSS gf180mcu_fd_sc_mcu7t5v0__fillcap_4
XFILLER_32_247 VDD VDD VSS VSS gf180mcu_fd_sc_mcu7t5v0__fillcap_64
X_0960_ _0960_/A1 _2179_/Q _1671_/A1 VDD VDD VSS VSS gf180mcu_fd_sc_mcu7t5v0__nand2_1
Xoutput217 _1549_/A1 wire258/I VDD VDD VSS VSS gf180mcu_fd_sc_mcu7t5v0__buf_1
Xoutput206 _2016_/Q wire354/I VDD VDD VSS VSS gf180mcu_fd_sc_mcu7t5v0__buf_1
X_1512_ _1526_/A1 _1920_/Q _1513_/A2 VDD VDD VSS VSS gf180mcu_fd_sc_mcu7t5v0__nand2_1
X_1443_ _2151_/D _2150_/D _1445_/S _1889_/D VDD VDD VSS VSS gf180mcu_fd_sc_mcu7t5v0__mux2_2
X_1374_ _2116_/Q _1179_/Z _1396_/A2 input50/Z _1379_/A1 VDD VDD VSS VSS gf180mcu_fd_sc_mcu7t5v0__aoi22_1
XFILLER_68_667 VDD VDD VSS VSS gf180mcu_fd_sc_mcu7t5v0__fillcap_16
XTAP_TAPCELL_ROW_66_835 VDD VSS gf180mcu_fd_sc_mcu7t5v0__filltie
XFILLER_95_486 VDD VDD VSS VSS gf180mcu_fd_sc_mcu7t5v0__fillcap_4
XFILLER_82_125 VDD VDD VSS VSS gf180mcu_fd_sc_mcu7t5v0__fill_1
XFILLER_48_391 VDD VDD VSS VSS gf180mcu_fd_sc_mcu7t5v0__fill_2
XFILLER_91_692 VDD VDD VSS VSS gf180mcu_fd_sc_mcu7t5v0__fill_2
XTAP_TAPCELL_ROW_21_415 VDD VSS gf180mcu_fd_sc_mcu7t5v0__filltie
Xclkbuf_5_19__f_periph_clk_i clkbuf_4_9_0_periph_clk_i/Z _2142_/CLK VDD VDD VSS VSS
+ gf180mcu_fd_sc_mcu7t5v0__clkbuf_16
Xfanout433 input2/Z _1332_/A3 VDD VDD VSS VSS gf180mcu_fd_sc_mcu7t5v0__dlya_1
Xfanout444 _2128_/RN _2126_/RN VDD VDD VSS VSS gf180mcu_fd_sc_mcu7t5v0__buf_1
Xfanout455 _2188_/RN _2182_/RN VDD VDD VSS VSS gf180mcu_fd_sc_mcu7t5v0__buf_1
Xfanout477 _2176_/RN _2163_/RN VDD VDD VSS VSS gf180mcu_fd_sc_mcu7t5v0__buf_1
XFILLER_58_166 VDD VDD VSS VSS gf180mcu_fd_sc_mcu7t5v0__fillcap_8
XFILLER_58_155 VDD VDD VSS VSS gf180mcu_fd_sc_mcu7t5v0__fillcap_4
XFILLER_46_306 VDD VDD VSS VSS gf180mcu_fd_sc_mcu7t5v0__fillcap_8
XFILLER_58_177 VDD VDD VSS VSS gf180mcu_fd_sc_mcu7t5v0__fillcap_8
XFILLER_46_317 VDD VDD VSS VSS gf180mcu_fd_sc_mcu7t5v0__fillcap_4
XFILLER_80_45 VDD VDD VSS VSS gf180mcu_fd_sc_mcu7t5v0__fill_2
XFILLER_80_34 VDD VDD VSS VSS gf180mcu_fd_sc_mcu7t5v0__fill_1
XFILLER_13_72 VDD VDD VSS VSS gf180mcu_fd_sc_mcu7t5v0__fillcap_32
XFILLER_6_413 VDD VDD VSS VSS gf180mcu_fd_sc_mcu7t5v0__fillcap_32
XFILLER_6_457 VDD VDD VSS VSS gf180mcu_fd_sc_mcu7t5v0__fillcap_16
XTAP_TAPCELL_ROW_9_295 VDD VSS gf180mcu_fd_sc_mcu7t5v0__filltie
XFILLER_77_486 VDD VDD VSS VSS gf180mcu_fd_sc_mcu7t5v0__fillcap_4
XFILLER_64_103 VDD VDD VSS VSS gf180mcu_fd_sc_mcu7t5v0__fill_2
X_1090_ _2097_/Q _2173_/Q _1091_/B2 VDD VDD VSS VSS gf180mcu_fd_sc_mcu7t5v0__nand2_1
XFILLER_73_692 VDD VDD VSS VSS gf180mcu_fd_sc_mcu7t5v0__fill_2
X_1992_ _1992_/D _2028_/RN _2191_/CLK _1992_/Q VDD VDD VSS VSS gf180mcu_fd_sc_mcu7t5v0__dffrnq_1
X_0943_ _2172_/Q _1156_/A1 VDD VDD VSS VSS gf180mcu_fd_sc_mcu7t5v0__clkinv_1
Xclkload10 _2182_/CLK clkload10/Z VDD VDD VSS VSS gf180mcu_fd_sc_mcu7t5v0__clkbuf_2
XFILLER_9_284 VDD VDD VSS VSS gf180mcu_fd_sc_mcu7t5v0__fill_1
XFILLER_87_206 VDD VDD VSS VSS gf180mcu_fd_sc_mcu7t5v0__fillcap_4
X_1426_ _1873_/Q _2057_/Q _1426_/S _1873_/D VDD VDD VSS VSS gf180mcu_fd_sc_mcu7t5v0__mux2_2
X_1357_ _2045_/Q _1325_/Z _1392_/B1 input89/Z _1360_/A1 VDD VDD VSS VSS gf180mcu_fd_sc_mcu7t5v0__aoi22_1
XTAP_TAPCELL_ROW_79_960 VDD VSS gf180mcu_fd_sc_mcu7t5v0__filltie
XFILLER_68_442 VDD VDD VSS VSS gf180mcu_fd_sc_mcu7t5v0__fillcap_8
XFILLER_28_317 VDD VDD VSS VSS gf180mcu_fd_sc_mcu7t5v0__fillcap_8
X_1288_ _2169_/Q _2170_/Q _2171_/Q _2172_/Q _1288_/Z VDD VDD VSS VSS gf180mcu_fd_sc_mcu7t5v0__and4_1
XTAP_TAPCELL_ROW_87_1037 VDD VSS gf180mcu_fd_sc_mcu7t5v0__filltie
XFILLER_83_489 VDD VDD VSS VSS gf180mcu_fd_sc_mcu7t5v0__fill_1
XFILLER_34_49 VDD VDD VSS VSS gf180mcu_fd_sc_mcu7t5v0__fill_1
XTAP_TAPCELL_ROW_34_540 VDD VSS gf180mcu_fd_sc_mcu7t5v0__filltie
Xclkload4 clkload4/I clkload4/Z VDD VDD VSS VSS gf180mcu_fd_sc_mcu7t5v0__clkbuf_2
XTAP_TAPCELL_ROW_98_1155 VDD VSS gf180mcu_fd_sc_mcu7t5v0__filltie
XTAP_TAPCELL_ROW_98_1144 VDD VSS gf180mcu_fd_sc_mcu7t5v0__filltie
XFILLER_50_37 VDD VDD VSS VSS gf180mcu_fd_sc_mcu7t5v0__fillcap_8
Xfanout252 _1816_/A1 _1822_/B VDD VDD VSS VSS gf180mcu_fd_sc_mcu7t5v0__dlyb_1
Xfanout263 wire266/I _1641_/S VDD VDD VSS VSS gf180mcu_fd_sc_mcu7t5v0__dlyb_1
XTAP_TAPCELL_ROW_6_265 VDD VSS gf180mcu_fd_sc_mcu7t5v0__filltie
XFILLER_59_464 VDD VDD VSS VSS gf180mcu_fd_sc_mcu7t5v0__fillcap_16
XFILLER_74_489 VDD VDD VSS VSS gf180mcu_fd_sc_mcu7t5v0__fillcap_8
XFILLER_55_692 VDD VDD VSS VSS gf180mcu_fd_sc_mcu7t5v0__fill_2
XFILLER_91_66 VDD VDD VSS VSS gf180mcu_fd_sc_mcu7t5v0__fillcap_4
XFILLER_42_342 VDD VDD VSS VSS gf180mcu_fd_sc_mcu7t5v0__fillcap_32
X_1211_ _2133_/Q _2134_/Q _2135_/Q _1201_/Z _1211_/Z VDD VDD VSS VSS gf180mcu_fd_sc_mcu7t5v0__and4_1
X_2191_ _2191_/D _2193_/RN _2191_/CLK _2191_/Q VDD VDD VSS VSS gf180mcu_fd_sc_mcu7t5v0__dffrnq_1
X_1142_ _1159_/A3 _1121_/Z _1142_/A3 _1142_/Z VDD VDD VSS VSS gf180mcu_fd_sc_mcu7t5v0__and3_1
XTAP_TAPCELL_ROW_76_930 VDD VSS gf180mcu_fd_sc_mcu7t5v0__filltie
X_1073_ _1073_/A1 _1072_/Z _1075_/A3 VDD VDD VSS VSS gf180mcu_fd_sc_mcu7t5v0__nand2_1
XTAP_TAPCELL_ROW_48_665 VDD VSS gf180mcu_fd_sc_mcu7t5v0__filltie
XFILLER_65_489 VDD VDD VSS VSS gf180mcu_fd_sc_mcu7t5v0__fill_1
XFILLER_65_478 VDD VDD VSS VSS gf180mcu_fd_sc_mcu7t5v0__fill_2
XFILLER_18_383 VDD VDD VSS VSS gf180mcu_fd_sc_mcu7t5v0__fill_2
XFILLER_33_342 VDD VDD VSS VSS gf180mcu_fd_sc_mcu7t5v0__fillcap_8
XFILLER_21_515 VDD VDD VSS VSS gf180mcu_fd_sc_mcu7t5v0__fillcap_4
XTAP_TAPCELL_ROW_31_510 VDD VSS gf180mcu_fd_sc_mcu7t5v0__filltie
XFILLER_60_183 VDD VDD VSS VSS gf180mcu_fd_sc_mcu7t5v0__fill_1
XFILLER_21_559 VDD VDD VSS VSS gf180mcu_fd_sc_mcu7t5v0__fill_1
X_1975_ _1975_/D _2097_/RN _1975_/CLK _1975_/Q VDD VDD VSS VSS gf180mcu_fd_sc_mcu7t5v0__dffrnq_1
XFILLER_60_194 VDD VDD VSS VSS gf180mcu_fd_sc_mcu7t5v0__fillcap_4
X_0926_ _2097_/Q _1134_/A1 VDD VDD VSS VSS gf180mcu_fd_sc_mcu7t5v0__clkinv_1
XFILLER_20_18 VDD VDD VSS VSS gf180mcu_fd_sc_mcu7t5v0__fill_2
XTAP_TAPCELL_ROW_93_1096 VDD VSS gf180mcu_fd_sc_mcu7t5v0__filltie
X_1409_ _1858_/Q _2058_/Q _1414_/S _1858_/D VDD VDD VSS VSS gf180mcu_fd_sc_mcu7t5v0__mux2_2
XPHY_EDGE_ROW_89_Right_89 VDD VSS gf180mcu_fd_sc_mcu7t5v0__endcap
XFILLER_75_209 VDD VDD VSS VSS gf180mcu_fd_sc_mcu7t5v0__fill_1
XFILLER_83_220 VDD VDD VSS VSS gf180mcu_fd_sc_mcu7t5v0__fill_2
XFILLER_71_404 VDD VDD VSS VSS gf180mcu_fd_sc_mcu7t5v0__fill_2
XFILLER_45_26 VDD VDD VSS VSS gf180mcu_fd_sc_mcu7t5v0__fill_1
XFILLER_44_607 VDD VDD VSS VSS gf180mcu_fd_sc_mcu7t5v0__fill_1
XFILLER_83_286 VDD VDD VSS VSS gf180mcu_fd_sc_mcu7t5v0__fill_2
XFILLER_43_139 VDD VDD VSS VSS gf180mcu_fd_sc_mcu7t5v0__fill_1
XTAP_TAPCELL_ROW_82_988 VDD VSS gf180mcu_fd_sc_mcu7t5v0__filltie
XPHY_EDGE_ROW_98_Right_98 VDD VSS gf180mcu_fd_sc_mcu7t5v0__endcap
XFILLER_61_69 VDD VDD VSS VSS gf180mcu_fd_sc_mcu7t5v0__fill_1
XFILLER_19_136 VDD VDD VSS VSS gf180mcu_fd_sc_mcu7t5v0__fillcap_4
XFILLER_34_139 VDD VDD VSS VSS gf180mcu_fd_sc_mcu7t5v0__fill_2
X_1760_ _1826_/A1 _1829_/A3 _1832_/A2 _1760_/Z VDD VDD VSS VSS gf180mcu_fd_sc_mcu7t5v0__and3_1
X_1691_ _1754_/A2 _1703_/C _2053_/Q _1691_/C _1698_/A2 VDD VDD VSS VSS gf180mcu_fd_sc_mcu7t5v0__aoi211_1
Xhold519 _2187_/Q _2186_/D VDD VDD VSS VSS gf180mcu_fd_sc_mcu7t5v0__dlyc_1
Xmax_cap249 _1704_/A2 _1705_/A1 VDD VDD VSS VSS gf180mcu_fd_sc_mcu7t5v0__dlyb_1
Xload_slew466 _1923_/RN _1918_/RN VDD VDD VSS VSS gf180mcu_fd_sc_mcu7t5v0__buf_2
X_2174_ _2174_/D _2174_/RN _2176_/CLK _2174_/Q VDD VDD VSS VSS gf180mcu_fd_sc_mcu7t5v0__dffrnq_1
X_1125_ _1259_/A1 _2089_/Q _2176_/Q _1126_/C VDD VDD VSS VSS gf180mcu_fd_sc_mcu7t5v0__aoi21_1
XTAP_TAPCELL_ROW_84_1007 VDD VSS gf180mcu_fd_sc_mcu7t5v0__filltie
XTAP_TAPCELL_ROW_0_216 VDD VSS gf180mcu_fd_sc_mcu7t5v0__filltie
XTAP_TAPCELL_ROW_0_205 VDD VSS gf180mcu_fd_sc_mcu7t5v0__filltie
XFILLER_93_562 VDD VDD VSS VSS gf180mcu_fd_sc_mcu7t5v0__fillcap_64
XFILLER_53_415 VDD VDD VSS VSS gf180mcu_fd_sc_mcu7t5v0__fillcap_4
X_1056_ _1895_/Q _1893_/Q _1892_/Q _1306_/S1 VDD VDD VSS VSS gf180mcu_fd_sc_mcu7t5v0__oai21_1
XFILLER_80_267 VDD VDD VSS VSS gf180mcu_fd_sc_mcu7t5v0__fill_2
XFILLER_21_345 VDD VDD VSS VSS gf180mcu_fd_sc_mcu7t5v0__fillcap_4
XFILLER_21_356 VDD VDD VSS VSS gf180mcu_fd_sc_mcu7t5v0__fill_1
X_1958_ _1958_/D _2127_/RN _2020_/CLK _1958_/Q VDD VDD VSS VSS gf180mcu_fd_sc_mcu7t5v0__dffrnq_1
X_1889_ _1889_/D _2151_/RN _2156_/CLK _2151_/D VDD VDD VSS VSS gf180mcu_fd_sc_mcu7t5v0__dffrnq_1
X_0909_ _2148_/Q _0986_/A1 VDD VDD VSS VSS gf180mcu_fd_sc_mcu7t5v0__clkinv_1
XTAP_TAPCELL_ROW_95_1114 VDD VSS gf180mcu_fd_sc_mcu7t5v0__filltie
XFILLER_88_312 VDD VDD VSS VSS gf180mcu_fd_sc_mcu7t5v0__fill_2
Xinput106 data_tx_i[4] _1573_/I0 VDD VDD VSS VSS gf180mcu_fd_sc_mcu7t5v0__dlyb_1
XFILLER_76_529 VDD VDD VSS VSS gf180mcu_fd_sc_mcu7t5v0__fill_1
XFILLER_69_570 VDD VDD VSS VSS gf180mcu_fd_sc_mcu7t5v0__fill_2
XFILLER_29_434 VDD VDD VSS VSS gf180mcu_fd_sc_mcu7t5v0__fillcap_4
XFILLER_29_445 VDD VDD VSS VSS gf180mcu_fd_sc_mcu7t5v0__fillcap_32
XFILLER_56_47 VDD VDD VSS VSS gf180mcu_fd_sc_mcu7t5v0__fill_1
XFILLER_84_573 VDD VDD VSS VSS gf180mcu_fd_sc_mcu7t5v0__fillcap_16
XFILLER_56_242 VDD VDD VSS VSS gf180mcu_fd_sc_mcu7t5v0__fill_2
XFILLER_71_212 VDD VDD VSS VSS gf180mcu_fd_sc_mcu7t5v0__fill_2
XTAP_TAPCELL_ROW_42_616 VDD VSS gf180mcu_fd_sc_mcu7t5v0__filltie
XFILLER_71_278 VDD VDD VSS VSS gf180mcu_fd_sc_mcu7t5v0__fill_2
XFILLER_12_356 VDD VDD VSS VSS gf180mcu_fd_sc_mcu7t5v0__fillcap_4
XFILLER_12_378 VDD VDD VSS VSS gf180mcu_fd_sc_mcu7t5v0__fillcap_4
XFILLER_21_72 VDD VDD VSS VSS gf180mcu_fd_sc_mcu7t5v0__fillcap_16
Xudma_uart_top_489 data_rx_o[13] VDD VDD VSS VSS gf180mcu_fd_sc_mcu7t5v0__tiel
XFILLER_4_522 VDD VDD VSS VSS gf180mcu_fd_sc_mcu7t5v0__fill_2
XFILLER_4_588 VDD VDD VSS VSS gf180mcu_fd_sc_mcu7t5v0__fillcap_4
XFILLER_67_529 VDD VDD VSS VSS gf180mcu_fd_sc_mcu7t5v0__fillcap_16
XTAP_TAPCELL_ROW_58_760 VDD VSS gf180mcu_fd_sc_mcu7t5v0__filltie
XFILLER_75_562 VDD VDD VSS VSS gf180mcu_fd_sc_mcu7t5v0__fillcap_8
XFILLER_35_415 VDD VDD VSS VSS gf180mcu_fd_sc_mcu7t5v0__fillcap_4
XFILLER_90_510 VDD VDD VSS VSS gf180mcu_fd_sc_mcu7t5v0__fill_2
XFILLER_43_492 VDD VDD VSS VSS gf180mcu_fd_sc_mcu7t5v0__fillcap_16
XFILLER_30_164 VDD VDD VSS VSS gf180mcu_fd_sc_mcu7t5v0__fillcap_8
XTAP_TAPCELL_ROW_13_340 VDD VSS gf180mcu_fd_sc_mcu7t5v0__filltie
X_1812_ _1815_/A1 _1926_/Q _1814_/A2 VDD VDD VSS VSS gf180mcu_fd_sc_mcu7t5v0__nand2_1
X_1743_ _1743_/A1 _1743_/A2 _1826_/A1 _1829_/A3 _1757_/A1 VDD VDD VSS VSS gf180mcu_fd_sc_mcu7t5v0__aoi22_1
XFILLER_7_360 VDD VDD VSS VSS gf180mcu_fd_sc_mcu7t5v0__fill_2
X_1674_ input17/Z _2041_/Q _1675_/S _2041_/D VDD VDD VSS VSS gf180mcu_fd_sc_mcu7t5v0__mux2_2
Xwire291 wire291/I data_rx_o[2] VDD VDD VSS VSS gf180mcu_fd_sc_mcu7t5v0__clkbuf_3
XTAP_TAPCELL_ROW_90_1066 VDD VSS gf180mcu_fd_sc_mcu7t5v0__filltie
XFILLER_98_643 VDD VDD VSS VSS gf180mcu_fd_sc_mcu7t5v0__fill_2
XFILLER_97_142 VDD VDD VSS VSS gf180mcu_fd_sc_mcu7t5v0__fillcap_64
Xload_slew274 _1603_/S _1672_/S VDD VDD VSS VSS gf180mcu_fd_sc_mcu7t5v0__buf_2
XFILLER_66_551 VDD VDD VSS VSS gf180mcu_fd_sc_mcu7t5v0__fill_2
X_2157_ _2157_/D _2081_/RN _2157_/CLK _2157_/Q VDD VDD VSS VSS gf180mcu_fd_sc_mcu7t5v0__dffsnq_1
XFILLER_53_212 VDD VDD VSS VSS gf180mcu_fd_sc_mcu7t5v0__fill_2
XFILLER_26_448 VDD VDD VSS VSS gf180mcu_fd_sc_mcu7t5v0__fillcap_4
X_2088_ _2088_/D _2097_/RN _2100_/CLK _2088_/Q VDD VDD VSS VSS gf180mcu_fd_sc_mcu7t5v0__dffrnq_1
X_1108_ _1108_/A1 _1108_/A2 _1108_/A3 _1108_/A4 _1109_/A2 VDD VDD VSS VSS gf180mcu_fd_sc_mcu7t5v0__nand4_1
X_1039_ _1039_/A1 _1039_/A2 _1039_/A3 _1038_/Z _1045_/B VDD VDD VSS VSS gf180mcu_fd_sc_mcu7t5v0__nand4_1
XFILLER_21_142 VDD VDD VSS VSS gf180mcu_fd_sc_mcu7t5v0__fillcap_16
XFILLER_22_676 VDD VDD VSS VSS gf180mcu_fd_sc_mcu7t5v0__fillcap_4
XFILLER_89_632 VDD VDD VSS VSS gf180mcu_fd_sc_mcu7t5v0__fillcap_32
XFILLER_67_46 VDD VDD VSS VSS gf180mcu_fd_sc_mcu7t5v0__fill_1
XFILLER_57_562 VDD VDD VSS VSS gf180mcu_fd_sc_mcu7t5v0__fillcap_8
XFILLER_72_532 VDD VDD VSS VSS gf180mcu_fd_sc_mcu7t5v0__fillcap_32
XFILLER_17_459 VDD VDD VSS VSS gf180mcu_fd_sc_mcu7t5v0__fillcap_16
XTAP_TAPCELL_ROW_27_465 VDD VSS gf180mcu_fd_sc_mcu7t5v0__filltie
XPHY_EDGE_ROW_17_Left_116 VDD VSS gf180mcu_fd_sc_mcu7t5v0__endcap
XFILLER_13_632 VDD VDD VSS VSS gf180mcu_fd_sc_mcu7t5v0__fillcap_32
XFILLER_25_492 VDD VDD VSS VSS gf180mcu_fd_sc_mcu7t5v0__fillcap_8
XFILLER_40_473 VDD VDD VSS VSS gf180mcu_fd_sc_mcu7t5v0__fill_2
XTAP_TAPCELL_ROW_10_310 VDD VSS gf180mcu_fd_sc_mcu7t5v0__filltie
XFILLER_59_8 VDD VDD VSS VSS gf180mcu_fd_sc_mcu7t5v0__fillcap_8
XPHY_EDGE_ROW_26_Left_125 VDD VSS gf180mcu_fd_sc_mcu7t5v0__endcap
X_1390_ input84/Z _1404_/A2 _1404_/B1 input54/Z _1392_/B1 input96/Z _1391_/A2 VDD
+ VDD VSS VSS gf180mcu_fd_sc_mcu7t5v0__aoi222_1
XFILLER_79_142 VDD VDD VSS VSS gf180mcu_fd_sc_mcu7t5v0__fillcap_8
XFILLER_94_101 VDD VDD VSS VSS gf180mcu_fd_sc_mcu7t5v0__fillcap_4
XFILLER_0_580 VDD VDD VSS VSS gf180mcu_fd_sc_mcu7t5v0__fillcap_32
X_2011_ _2011_/D _2117_/RN _2021_/CLK _2011_/Q VDD VDD VSS VSS gf180mcu_fd_sc_mcu7t5v0__dffrnq_1
XFILLER_35_212 VDD VDD VSS VSS gf180mcu_fd_sc_mcu7t5v0__fillcap_16
XPHY_EDGE_ROW_35_Left_134 VDD VSS gf180mcu_fd_sc_mcu7t5v0__endcap
XFILLER_50_204 VDD VDD VSS VSS gf180mcu_fd_sc_mcu7t5v0__fill_2
XFILLER_92_2 VDD VDD VSS VSS gf180mcu_fd_sc_mcu7t5v0__fillcap_32
XTAP_TAPCELL_ROW_61_788 VDD VSS gf180mcu_fd_sc_mcu7t5v0__filltie
Xclkbuf_5_27__f_periph_clk_i clkbuf_4_13_0_periph_clk_i/Z _2170_/CLK VDD VDD VSS VSS
+ gf180mcu_fd_sc_mcu7t5v0__clkbuf_16
XFILLER_8_691 VDD VDD VSS VSS gf180mcu_fd_sc_mcu7t5v0__fill_2
X_1726_ _1725_/Z _1718_/S _2064_/Q _2064_/D VDD VDD VSS VSS gf180mcu_fd_sc_mcu7t5v0__mux2_2
XPHY_EDGE_ROW_44_Left_143 VDD VSS gf180mcu_fd_sc_mcu7t5v0__endcap
X_1657_ _2027_/Q input36/Z _1662_/S _2027_/D VDD VDD VSS VSS gf180mcu_fd_sc_mcu7t5v0__mux2_2
X_1588_ _1962_/Q input15/Z _1601_/S _1962_/D VDD VDD VSS VSS gf180mcu_fd_sc_mcu7t5v0__mux2_2
XTAP_TAPCELL_ROW_69_866 VDD VSS gf180mcu_fd_sc_mcu7t5v0__filltie
XFILLER_39_562 VDD VDD VSS VSS gf180mcu_fd_sc_mcu7t5v0__fillcap_32
XPHY_EDGE_ROW_53_Left_152 VDD VSS gf180mcu_fd_sc_mcu7t5v0__endcap
XFILLER_81_340 VDD VDD VSS VSS gf180mcu_fd_sc_mcu7t5v0__fillcap_8
XTAP_TAPCELL_ROW_52_711 VDD VSS gf180mcu_fd_sc_mcu7t5v0__filltie
XFILLER_41_237 VDD VDD VSS VSS gf180mcu_fd_sc_mcu7t5v0__fillcap_32
XFILLER_10_613 VDD VDD VSS VSS gf180mcu_fd_sc_mcu7t5v0__fillcap_32
XPHY_EDGE_ROW_62_Left_161 VDD VSS gf180mcu_fd_sc_mcu7t5v0__endcap
XFILLER_78_45 VDD VDD VSS VSS gf180mcu_fd_sc_mcu7t5v0__fillcap_4
XFILLER_78_34 VDD VDD VSS VSS gf180mcu_fd_sc_mcu7t5v0__fill_1
XFILLER_77_602 VDD VDD VSS VSS gf180mcu_fd_sc_mcu7t5v0__fill_2
XFILLER_76_101 VDD VDD VSS VSS gf180mcu_fd_sc_mcu7t5v0__fillcap_4
XPHY_EDGE_ROW_71_Left_170 VDD VSS gf180mcu_fd_sc_mcu7t5v0__endcap
XFILLER_17_212 VDD VDD VSS VSS gf180mcu_fd_sc_mcu7t5v0__fillcap_8
XFILLER_45_543 VDD VDD VSS VSS gf180mcu_fd_sc_mcu7t5v0__fill_2
XFILLER_17_278 VDD VDD VSS VSS gf180mcu_fd_sc_mcu7t5v0__fill_2
XFILLER_72_384 VDD VDD VSS VSS gf180mcu_fd_sc_mcu7t5v0__fill_1
XFILLER_9_422 VDD VDD VSS VSS gf180mcu_fd_sc_mcu7t5v0__fillcap_16
Xoutput207 _1305_/Z wire293/I VDD VDD VSS VSS gf180mcu_fd_sc_mcu7t5v0__buf_1
X_1511_ _1000_/Z _1474_/B _1511_/B _1511_/C _1526_/A1 VDD VDD VSS VSS gf180mcu_fd_sc_mcu7t5v0__oai211_1
Xoutput218 _0963_/Z wire237/I VDD VDD VSS VSS gf180mcu_fd_sc_mcu7t5v0__buf_1
X_1442_ _2150_/D _2153_/D _1445_/S _1888_/D VDD VDD VSS VSS gf180mcu_fd_sc_mcu7t5v0__mux2_2
X_1373_ input98/Z _1376_/A2 _1373_/A3 _1377_/A1 VDD VDD VSS VSS gf180mcu_fd_sc_mcu7t5v0__nand3_1
XTAP_TAPCELL_ROW_66_836 VDD VSS gf180mcu_fd_sc_mcu7t5v0__filltie
XFILLER_51_557 VDD VDD VSS VSS gf180mcu_fd_sc_mcu7t5v0__fill_2
XTAP_TAPCELL_ROW_21_416 VDD VSS gf180mcu_fd_sc_mcu7t5v0__filltie
X_1709_ _2059_/Q _2058_/Q _1710_/S _2058_/D VDD VDD VSS VSS gf180mcu_fd_sc_mcu7t5v0__mux2_2
Xfanout423 _1354_/A2 _1376_/A2 VDD VDD VSS VSS gf180mcu_fd_sc_mcu7t5v0__dlyb_1
Xfanout434 input2/Z _1673_/A2 VDD VDD VSS VSS gf180mcu_fd_sc_mcu7t5v0__dlyb_1
Xfanout445 _2190_/RN _2128_/RN VDD VDD VSS VSS gf180mcu_fd_sc_mcu7t5v0__buf_1
Xfanout456 _2188_/RN _2101_/RN VDD VDD VSS VSS gf180mcu_fd_sc_mcu7t5v0__buf_1
XFILLER_58_101 VDD VDD VSS VSS gf180mcu_fd_sc_mcu7t5v0__fillcap_4
XFILLER_48_37 VDD VDD VSS VSS gf180mcu_fd_sc_mcu7t5v0__fillcap_16
Xfanout467 _1926_/RN _2133_/RN VDD VDD VSS VSS gf180mcu_fd_sc_mcu7t5v0__buf_1
Xfanout478 input111/Z _2176_/RN VDD VDD VSS VSS gf180mcu_fd_sc_mcu7t5v0__dlyb_1
XFILLER_86_454 VDD VDD VSS VSS gf180mcu_fd_sc_mcu7t5v0__fill_1
XFILLER_64_14 VDD VDD VSS VSS gf180mcu_fd_sc_mcu7t5v0__fill_2
XTAP_TAPCELL_ROW_37_560 VDD VSS gf180mcu_fd_sc_mcu7t5v0__filltie
XFILLER_82_693 VDD VDD VSS VSS gf180mcu_fd_sc_mcu7t5v0__fill_1
XFILLER_42_524 VDD VDD VSS VSS gf180mcu_fd_sc_mcu7t5v0__fill_1
XFILLER_10_432 VDD VDD VSS VSS gf180mcu_fd_sc_mcu7t5v0__fillcap_4
XFILLER_10_465 VDD VDD VSS VSS gf180mcu_fd_sc_mcu7t5v0__fillcap_4
XFILLER_6_403 VDD VDD VSS VSS gf180mcu_fd_sc_mcu7t5v0__fill_2
XFILLER_89_66 VDD VDD VSS VSS gf180mcu_fd_sc_mcu7t5v0__fillcap_4
XTAP_TAPCELL_ROW_9_296 VDD VSS gf180mcu_fd_sc_mcu7t5v0__filltie
XFILLER_64_115 VDD VDD VSS VSS gf180mcu_fd_sc_mcu7t5v0__fillcap_16
X_1991_ _1991_/D _2127_/RN _2020_/CLK _1991_/Q VDD VDD VSS VSS gf180mcu_fd_sc_mcu7t5v0__dffrnq_1
XTAP_TAPCELL_ROW_71_883 VDD VSS gf180mcu_fd_sc_mcu7t5v0__filltie
XFILLER_60_387 VDD VDD VSS VSS gf180mcu_fd_sc_mcu7t5v0__fillcap_64
X_0942_ _2170_/Q _1281_/B VDD VDD VSS VSS gf180mcu_fd_sc_mcu7t5v0__clkinv_1
Xclkload11 _2154_/CLK clkload11/Z VDD VDD VSS VSS gf180mcu_fd_sc_mcu7t5v0__clkbuf_2
X_1425_ _1872_/Q _2056_/Q _1425_/S _1872_/D VDD VDD VSS VSS gf180mcu_fd_sc_mcu7t5v0__mux2_2
X_1356_ _1356_/A1 _1355_/Z _1356_/ZN VDD VDD VSS VSS gf180mcu_fd_sc_mcu7t5v0__nand2_1
XTAP_TAPCELL_ROW_79_961 VDD VSS gf180mcu_fd_sc_mcu7t5v0__filltie
XFILLER_68_454 VDD VDD VSS VSS gf180mcu_fd_sc_mcu7t5v0__fill_1
X_1287_ _2171_/Q _1287_/A2 _2172_/Q _1291_/A2 VDD VDD VSS VSS gf180mcu_fd_sc_mcu7t5v0__aoi21_1
XTAP_TAPCELL_ROW_87_1038 VDD VSS gf180mcu_fd_sc_mcu7t5v0__filltie
XFILLER_70_107 VDD VDD VSS VSS gf180mcu_fd_sc_mcu7t5v0__fill_1
XFILLER_64_693 VDD VDD VSS VSS gf180mcu_fd_sc_mcu7t5v0__fill_1
XFILLER_32_590 VDD VDD VSS VSS gf180mcu_fd_sc_mcu7t5v0__fillcap_4
Xclkload5 clkload5/I clkload5/Z VDD VDD VSS VSS gf180mcu_fd_sc_mcu7t5v0__clkbuf_2
XTAP_TAPCELL_ROW_98_1145 VDD VSS gf180mcu_fd_sc_mcu7t5v0__filltie
XTAP_TAPCELL_ROW_98_1156 VDD VSS gf180mcu_fd_sc_mcu7t5v0__filltie
XTAP_TAPCELL_ROW_6_266 VDD VSS gf180mcu_fd_sc_mcu7t5v0__filltie
XFILLER_19_329 VDD VDD VSS VSS gf180mcu_fd_sc_mcu7t5v0__fill_2
XFILLER_74_402 VDD VDD VSS VSS gf180mcu_fd_sc_mcu7t5v0__fillcap_4
XFILLER_47_616 VDD VDD VSS VSS gf180mcu_fd_sc_mcu7t5v0__fillcap_8
XFILLER_75_68 VDD VDD VSS VSS gf180mcu_fd_sc_mcu7t5v0__fill_2
XFILLER_74_457 VDD VDD VSS VSS gf180mcu_fd_sc_mcu7t5v0__fillcap_32
XFILLER_30_505 VDD VDD VSS VSS gf180mcu_fd_sc_mcu7t5v0__fillcap_4
XFILLER_42_387 VDD VDD VSS VSS gf180mcu_fd_sc_mcu7t5v0__fillcap_64
XTAP_TAPCELL_ROW_40_588 VDD VSS gf180mcu_fd_sc_mcu7t5v0__filltie
XFILLER_97_538 VDD VDD VSS VSS gf180mcu_fd_sc_mcu7t5v0__fillcap_16
X_2190_ _2194_/Q _2190_/RN _2191_/CLK _2190_/Q VDD VDD VSS VSS gf180mcu_fd_sc_mcu7t5v0__dffrnq_1
X_1210_ _2134_/Q _1205_/Z _2135_/Q _1212_/A2 VDD VDD VSS VSS gf180mcu_fd_sc_mcu7t5v0__aoi21_1
X_1141_ _1146_/A1 _2164_/Q _2173_/Q _1141_/B2 _1303_/A1 _2100_/Q _1142_/A3 VDD VDD
+ VSS VSS gf180mcu_fd_sc_mcu7t5v0__aoi222_1
XFILLER_1_54 VDD VDD VSS VSS gf180mcu_fd_sc_mcu7t5v0__fill_1
XTAP_TAPCELL_ROW_76_931 VDD VSS gf180mcu_fd_sc_mcu7t5v0__filltie
XFILLER_1_76 VDD VDD VSS VSS gf180mcu_fd_sc_mcu7t5v0__fill_1
X_1072_ _2088_/Q _2164_/Q _1072_/Z VDD VDD VSS VSS gf180mcu_fd_sc_mcu7t5v0__or2_1
XTAP_TAPCELL_ROW_48_666 VDD VSS gf180mcu_fd_sc_mcu7t5v0__filltie
XPHY_EDGE_ROW_9_Left_108 VDD VSS gf180mcu_fd_sc_mcu7t5v0__endcap
XFILLER_52_107 VDD VDD VSS VSS gf180mcu_fd_sc_mcu7t5v0__fillcap_8
XFILLER_80_438 VDD VDD VSS VSS gf180mcu_fd_sc_mcu7t5v0__fillcap_16
X_1974_ _1974_/D _2174_/RN _1975_/CLK _1974_/Q VDD VDD VSS VSS gf180mcu_fd_sc_mcu7t5v0__dffrnq_1
XTAP_TAPCELL_ROW_31_511 VDD VSS gf180mcu_fd_sc_mcu7t5v0__filltie
X_0925_ _2095_/Q _1153_/A1 VDD VDD VSS VSS gf180mcu_fd_sc_mcu7t5v0__clkinv_1
Xclkbuf_4_0_0_periph_clk_i clkbuf_0_periph_clk_i/Z clkbuf_4_0_0_periph_clk_i/Z VDD
+ VDD VSS VSS gf180mcu_fd_sc_mcu7t5v0__clkbuf_2
XTAP_TAPCELL_ROW_93_1097 VDD VSS gf180mcu_fd_sc_mcu7t5v0__filltie
XFILLER_88_527 VDD VDD VSS VSS gf180mcu_fd_sc_mcu7t5v0__fill_2
X_1408_ _1857_/Q _2057_/Q _1412_/S _1857_/D VDD VDD VSS VSS gf180mcu_fd_sc_mcu7t5v0__mux2_2
X_1339_ _2035_/Q _1376_/A2 _1373_/A3 _1329_/Z _1340_/A3 VDD VDD VSS VSS gf180mcu_fd_sc_mcu7t5v0__nand4_1
XTAP_TAPCELL_ROW_19_390 VDD VSS gf180mcu_fd_sc_mcu7t5v0__filltie
XFILLER_64_490 VDD VDD VSS VSS gf180mcu_fd_sc_mcu7t5v0__fill_2
XFILLER_52_663 VDD VDD VSS VSS gf180mcu_fd_sc_mcu7t5v0__fill_2
XFILLER_12_527 VDD VDD VSS VSS gf180mcu_fd_sc_mcu7t5v0__fillcap_16
XFILLER_24_387 VDD VDD VSS VSS gf180mcu_fd_sc_mcu7t5v0__fillcap_4
XTAP_TAPCELL_ROW_82_989 VDD VSS gf180mcu_fd_sc_mcu7t5v0__filltie
XFILLER_79_538 VDD VDD VSS VSS gf180mcu_fd_sc_mcu7t5v0__fillcap_16
XFILLER_86_34 VDD VDD VSS VSS gf180mcu_fd_sc_mcu7t5v0__fill_1
XFILLER_94_519 VDD VDD VSS VSS gf180mcu_fd_sc_mcu7t5v0__fillcap_4
XFILLER_19_72 VDD VDD VSS VSS gf180mcu_fd_sc_mcu7t5v0__fillcap_64
XFILLER_47_446 VDD VDD VSS VSS gf180mcu_fd_sc_mcu7t5v0__fill_2
XFILLER_34_107 VDD VDD VSS VSS gf180mcu_fd_sc_mcu7t5v0__fillcap_32
XTAP_TAPCELL_ROW_45_636 VDD VSS gf180mcu_fd_sc_mcu7t5v0__filltie
XFILLER_70_471 VDD VDD VSS VSS gf180mcu_fd_sc_mcu7t5v0__fill_1
X_1690_ _1690_/A1 _1690_/A2 _2052_/D VDD VDD VSS VSS gf180mcu_fd_sc_mcu7t5v0__nor2_1
XFILLER_7_575 VDD VDD VSS VSS gf180mcu_fd_sc_mcu7t5v0__fillcap_16
XFILLER_51_92 VDD VDD VSS VSS gf180mcu_fd_sc_mcu7t5v0__fill_1
Xmax_cap228 _1823_/S _1810_/A2 VDD VDD VSS VSS gf180mcu_fd_sc_mcu7t5v0__buf_2
XFILLER_78_571 VDD VDD VSS VSS gf180mcu_fd_sc_mcu7t5v0__fill_2
X_2173_ _2173_/D _2174_/RN _2173_/CLK _2173_/Q VDD VDD VSS VSS gf180mcu_fd_sc_mcu7t5v0__dffrnq_1
XFILLER_38_446 VDD VDD VSS VSS gf180mcu_fd_sc_mcu7t5v0__fillcap_8
XFILLER_38_424 VDD VDD VSS VSS gf180mcu_fd_sc_mcu7t5v0__fillcap_8
X_1124_ _2096_/Q _2171_/Q _1124_/Z VDD VDD VSS VSS gf180mcu_fd_sc_mcu7t5v0__and2_1
XTAP_TAPCELL_ROW_0_217 VDD VSS gf180mcu_fd_sc_mcu7t5v0__filltie
XTAP_TAPCELL_ROW_0_206 VDD VSS gf180mcu_fd_sc_mcu7t5v0__filltie
X_1055_ _2151_/D _2150_/D _1406_/A2 VDD VDD VSS VSS gf180mcu_fd_sc_mcu7t5v0__nand2_1
XTAP_TAPCELL_ROW_84_1008 VDD VSS gf180mcu_fd_sc_mcu7t5v0__filltie
XFILLER_65_298 VDD VDD VSS VSS gf180mcu_fd_sc_mcu7t5v0__fillcap_4
XTAP_TAPCELL_ROW_16_360 VDD VSS gf180mcu_fd_sc_mcu7t5v0__filltie
XFILLER_31_18 VDD VDD VSS VSS gf180mcu_fd_sc_mcu7t5v0__fillcap_32
X_1957_ _1957_/D _1957_/RN _2128_/CLK _1957_/Q VDD VDD VSS VSS gf180mcu_fd_sc_mcu7t5v0__dffrnq_1
X_1888_ _1888_/D _2151_/RN _2156_/CLK _2150_/D VDD VDD VSS VSS gf180mcu_fd_sc_mcu7t5v0__dffrnq_1
X_0908_ _2146_/Q _0990_/A1 VDD VDD VSS VSS gf180mcu_fd_sc_mcu7t5v0__clkinv_1
XTAP_TAPCELL_ROW_95_1115 VDD VSS gf180mcu_fd_sc_mcu7t5v0__filltie
Xinput107 data_tx_i[5] _1574_/I0 VDD VDD VSS VSS gf180mcu_fd_sc_mcu7t5v0__dlyb_1
XFILLER_56_37 VDD VDD VSS VSS gf180mcu_fd_sc_mcu7t5v0__fillcap_8
XFILLER_84_541 VDD VDD VSS VSS gf180mcu_fd_sc_mcu7t5v0__fillcap_32
XFILLER_16_107 VDD VDD VSS VSS gf180mcu_fd_sc_mcu7t5v0__fillcap_8
XFILLER_44_416 VDD VDD VSS VSS gf180mcu_fd_sc_mcu7t5v0__fill_1
XFILLER_72_47 VDD VDD VSS VSS gf180mcu_fd_sc_mcu7t5v0__fill_1
XFILLER_40_633 VDD VDD VSS VSS gf180mcu_fd_sc_mcu7t5v0__fill_2
XFILLER_8_328 VDD VDD VSS VSS gf180mcu_fd_sc_mcu7t5v0__fillcap_4
XFILLER_8_317 VDD VDD VSS VSS gf180mcu_fd_sc_mcu7t5v0__fillcap_4
XFILLER_8_306 VDD VDD VSS VSS gf180mcu_fd_sc_mcu7t5v0__fillcap_8
XTAP_TAPCELL_ROW_50_683 VDD VSS gf180mcu_fd_sc_mcu7t5v0__filltie
Xudma_uart_top_479 cfg_rx_datasize_o[1] VDD VDD VSS VSS gf180mcu_fd_sc_mcu7t5v0__tiel
XFILLER_97_66 VDD VDD VSS VSS gf180mcu_fd_sc_mcu7t5v0__fillcap_4
XTAP_TAPCELL_ROW_58_761 VDD VSS gf180mcu_fd_sc_mcu7t5v0__filltie
XFILLER_35_438 VDD VDD VSS VSS gf180mcu_fd_sc_mcu7t5v0__fill_2
X_1811_ _1826_/A1 _1313_/Z _2078_/Q _1811_/A4 _1817_/C VDD VDD VSS VSS gf180mcu_fd_sc_mcu7t5v0__nand4_1
X_1742_ _2070_/Q _1756_/A1 _1742_/B _1743_/A2 VDD VDD VSS VSS gf180mcu_fd_sc_mcu7t5v0__aoi21_1
X_1673_ input1/Z _1673_/A2 _1673_/A3 _1673_/A4 _1675_/S VDD VDD VSS VSS gf180mcu_fd_sc_mcu7t5v0__nand4_1
Xwire292 wire292/I data_rx_o[1] VDD VDD VSS VSS gf180mcu_fd_sc_mcu7t5v0__clkbuf_3
XFILLER_7_394 VDD VDD VSS VSS gf180mcu_fd_sc_mcu7t5v0__fillcap_4
Xload_slew264 _1641_/S _1647_/S VDD VDD VSS VSS gf180mcu_fd_sc_mcu7t5v0__buf_4
Xload_slew253 _1440_/S _1441_/S VDD VDD VSS VSS gf180mcu_fd_sc_mcu7t5v0__buf_2
XTAP_TAPCELL_ROW_90_1067 VDD VSS gf180mcu_fd_sc_mcu7t5v0__filltie
XFILLER_38_243 VDD VDD VSS VSS gf180mcu_fd_sc_mcu7t5v0__fill_2
XFILLER_26_427 VDD VDD VSS VSS gf180mcu_fd_sc_mcu7t5v0__fill_1
X_2156_ _2156_/D _2156_/RN _2156_/CLK _2156_/Q VDD VDD VSS VSS gf180mcu_fd_sc_mcu7t5v0__dffrnq_1
XFILLER_93_371 VDD VDD VSS VSS gf180mcu_fd_sc_mcu7t5v0__fillcap_8
X_2087_ _2087_/D _2136_/RN _2133_/CLK _2087_/Q VDD VDD VSS VSS gf180mcu_fd_sc_mcu7t5v0__dffrnq_1
X_1107_ _1108_/A1 _1108_/A2 _1108_/A3 _1108_/A4 _1107_/Z VDD VDD VSS VSS gf180mcu_fd_sc_mcu7t5v0__and4_1
XPHY_EDGE_ROW_5_Right_5 VDD VSS gf180mcu_fd_sc_mcu7t5v0__endcap
Xudma_uart_top cfg_rx_datasize_o[0] VDD VDD VSS VSS gf180mcu_fd_sc_mcu7t5v0__tiel
X_1038_ _1038_/A1 _1038_/A2 _1038_/A3 _1038_/A4 _1038_/Z VDD VDD VSS VSS gf180mcu_fd_sc_mcu7t5v0__and4_1
XFILLER_53_279 VDD VDD VSS VSS gf180mcu_fd_sc_mcu7t5v0__fill_1
XFILLER_89_688 VDD VDD VSS VSS gf180mcu_fd_sc_mcu7t5v0__fillcap_4
XFILLER_67_36 VDD VDD VSS VSS gf180mcu_fd_sc_mcu7t5v0__fillcap_8
XFILLER_49_508 VDD VDD VSS VSS gf180mcu_fd_sc_mcu7t5v0__fillcap_32
XTAP_TAPCELL_ROW_55_731 VDD VSS gf180mcu_fd_sc_mcu7t5v0__filltie
XTAP_TAPCELL_ROW_27_466 VDD VSS gf180mcu_fd_sc_mcu7t5v0__filltie
XFILLER_9_604 VDD VDD VSS VSS gf180mcu_fd_sc_mcu7t5v0__fillcap_16
XFILLER_13_688 VDD VDD VSS VSS gf180mcu_fd_sc_mcu7t5v0__fillcap_4
XFILLER_32_83 VDD VDD VSS VSS gf180mcu_fd_sc_mcu7t5v0__fill_1
XTAP_TAPCELL_ROW_10_311 VDD VSS gf180mcu_fd_sc_mcu7t5v0__filltie
Xclkbuf_5_14__f_periph_clk_i clkbuf_4_7_0_periph_clk_i/Z _2057_/CLK VDD VDD VSS VSS
+ gf180mcu_fd_sc_mcu7t5v0__clkbuf_16
XFILLER_79_121 VDD VDD VSS VSS gf180mcu_fd_sc_mcu7t5v0__fillcap_16
XFILLER_67_338 VDD VDD VSS VSS gf180mcu_fd_sc_mcu7t5v0__fillcap_8
X_2010_ _2010_/D _2028_/RN _2021_/CLK _2010_/Q VDD VDD VSS VSS gf180mcu_fd_sc_mcu7t5v0__dffrnq_1
XFILLER_63_522 VDD VDD VSS VSS gf180mcu_fd_sc_mcu7t5v0__fill_2
XFILLER_63_511 VDD VDD VSS VSS gf180mcu_fd_sc_mcu7t5v0__fill_2
XFILLER_90_341 VDD VDD VSS VSS gf180mcu_fd_sc_mcu7t5v0__fillcap_16
XFILLER_35_279 VDD VDD VSS VSS gf180mcu_fd_sc_mcu7t5v0__fill_1
XTAP_TAPCELL_ROW_61_789 VDD VSS gf180mcu_fd_sc_mcu7t5v0__filltie
XFILLER_85_2 VDD VDD VSS VSS gf180mcu_fd_sc_mcu7t5v0__fillcap_64
X_1725_ _2160_/Q _1728_/A1 _1733_/A2 _1733_/A4 _1725_/Z VDD VDD VSS VSS gf180mcu_fd_sc_mcu7t5v0__and4_1
X_1656_ _2026_/Q input35/Z _1664_/S _2026_/D VDD VDD VSS VSS gf180mcu_fd_sc_mcu7t5v0__mux2_2
X_1587_ _1961_/Q input14/Z _1587_/S _1961_/D VDD VDD VSS VSS gf180mcu_fd_sc_mcu7t5v0__mux2_2
XTAP_TAPCELL_ROW_69_867 VDD VSS gf180mcu_fd_sc_mcu7t5v0__filltie
XFILLER_66_360 VDD VDD VSS VSS gf180mcu_fd_sc_mcu7t5v0__fill_1
XFILLER_54_522 VDD VDD VSS VSS gf180mcu_fd_sc_mcu7t5v0__fill_2
X_2139_ _2139_/D _2139_/RN _2142_/CLK _2139_/Q VDD VDD VSS VSS gf180mcu_fd_sc_mcu7t5v0__dffrnq_1
XFILLER_94_691 VDD VDD VSS VSS gf180mcu_fd_sc_mcu7t5v0__fill_2
XFILLER_14_419 VDD VDD VSS VSS gf180mcu_fd_sc_mcu7t5v0__fillcap_4
XFILLER_81_352 VDD VDD VSS VSS gf180mcu_fd_sc_mcu7t5v0__fill_2
XTAP_TAPCELL_ROW_24_436 VDD VSS gf180mcu_fd_sc_mcu7t5v0__filltie
XFILLER_89_485 VDD VDD VSS VSS gf180mcu_fd_sc_mcu7t5v0__fillcap_4
XFILLER_94_34 VDD VDD VSS VSS gf180mcu_fd_sc_mcu7t5v0__fill_1
XFILLER_85_680 VDD VDD VSS VSS gf180mcu_fd_sc_mcu7t5v0__fillcap_8
XFILLER_45_511 VDD VDD VSS VSS gf180mcu_fd_sc_mcu7t5v0__fillcap_32
XFILLER_27_72 VDD VDD VSS VSS gf180mcu_fd_sc_mcu7t5v0__fillcap_4
XFILLER_9_401 VDD VDD VSS VSS gf180mcu_fd_sc_mcu7t5v0__fill_2
XFILLER_40_271 VDD VDD VSS VSS gf180mcu_fd_sc_mcu7t5v0__fill_2
Xoutput208 _1306_/Z wire292/I VDD VDD VSS VSS gf180mcu_fd_sc_mcu7t5v0__buf_1
X_1510_ _1511_/B _1510_/A2 _1458_/Z _1511_/C _1513_/A1 VDD VDD VSS VSS gf180mcu_fd_sc_mcu7t5v0__nand4_1
Xoutput219 _0965_/ZN wire284/I VDD VDD VSS VSS gf180mcu_fd_sc_mcu7t5v0__buf_1
XFILLER_5_684 VDD VDD VSS VSS gf180mcu_fd_sc_mcu7t5v0__fill_2
X_1441_ _2063_/Q _1887_/Q _1441_/S _1887_/D VDD VDD VSS VSS gf180mcu_fd_sc_mcu7t5v0__mux2_2
X_1372_ _1372_/A1 _1372_/A2 _1372_/A3 _1372_/ZN VDD VDD VSS VSS gf180mcu_fd_sc_mcu7t5v0__nand3_1
XFILLER_95_433 VDD VDD VSS VSS gf180mcu_fd_sc_mcu7t5v0__fill_2
XFILLER_83_606 VDD VDD VSS VSS gf180mcu_fd_sc_mcu7t5v0__fill_2
XFILLER_36_511 VDD VDD VSS VSS gf180mcu_fd_sc_mcu7t5v0__fillcap_8
XTAP_TAPCELL_ROW_66_837 VDD VSS gf180mcu_fd_sc_mcu7t5v0__filltie
XFILLER_83_628 VDD VDD VSS VSS gf180mcu_fd_sc_mcu7t5v0__fill_2
XFILLER_76_691 VDD VDD VSS VSS gf180mcu_fd_sc_mcu7t5v0__fill_2
XFILLER_75_190 VDD VDD VSS VSS gf180mcu_fd_sc_mcu7t5v0__fillcap_8
XFILLER_63_352 VDD VDD VSS VSS gf180mcu_fd_sc_mcu7t5v0__fillcap_8
XFILLER_90_171 VDD VDD VSS VSS gf180mcu_fd_sc_mcu7t5v0__fillcap_4
XFILLER_16_290 VDD VDD VSS VSS gf180mcu_fd_sc_mcu7t5v0__fillcap_4
XFILLER_31_282 VDD VDD VSS VSS gf180mcu_fd_sc_mcu7t5v0__fillcap_32
X_1708_ _2058_/Q _2057_/Q _1708_/S _2057_/D VDD VDD VSS VSS gf180mcu_fd_sc_mcu7t5v0__mux2_2
X_1639_ _2010_/Q input31/Z _1647_/S _2010_/D VDD VDD VSS VSS gf180mcu_fd_sc_mcu7t5v0__mux2_2
Xfanout424 _1195_/A4 _1191_/A4 VDD VDD VSS VSS gf180mcu_fd_sc_mcu7t5v0__dlyb_1
Xfanout435 _2033_/RN _2018_/RN VDD VDD VSS VSS gf180mcu_fd_sc_mcu7t5v0__buf_1
Xfanout446 _2190_/RN _2111_/RN VDD VDD VSS VSS gf180mcu_fd_sc_mcu7t5v0__dlyb_1
Xfanout457 fanout458/Z _2047_/RN VDD VDD VSS VSS gf180mcu_fd_sc_mcu7t5v0__buf_1
XFILLER_98_282 VDD VDD VSS VSS gf180mcu_fd_sc_mcu7t5v0__fill_2
Xfanout468 _1926_/RN _2130_/RN VDD VDD VSS VSS gf180mcu_fd_sc_mcu7t5v0__dlyb_1
XFILLER_67_680 VDD VDD VSS VSS gf180mcu_fd_sc_mcu7t5v0__fillcap_8
XFILLER_73_138 VDD VDD VSS VSS gf180mcu_fd_sc_mcu7t5v0__fill_2
XFILLER_39_393 VDD VDD VSS VSS gf180mcu_fd_sc_mcu7t5v0__fill_2
XFILLER_64_37 VDD VDD VSS VSS gf180mcu_fd_sc_mcu7t5v0__fillcap_8
XTAP_TAPCELL_ROW_37_561 VDD VSS gf180mcu_fd_sc_mcu7t5v0__filltie
XFILLER_82_683 VDD VDD VSS VSS gf180mcu_fd_sc_mcu7t5v0__fillcap_8
XFILLER_80_47 VDD VDD VSS VSS gf180mcu_fd_sc_mcu7t5v0__fill_1
XFILLER_10_444 VDD VDD VSS VSS gf180mcu_fd_sc_mcu7t5v0__fill_1
XFILLER_22_271 VDD VDD VSS VSS gf180mcu_fd_sc_mcu7t5v0__fill_2
XTAP_TAPCELL_ROW_9_297 VDD VSS gf180mcu_fd_sc_mcu7t5v0__filltie
XFILLER_89_282 VDD VDD VSS VSS gf180mcu_fd_sc_mcu7t5v0__fillcap_16
XFILLER_77_422 VDD VDD VSS VSS gf180mcu_fd_sc_mcu7t5v0__fillcap_16
XFILLER_49_135 VDD VDD VSS VSS gf180mcu_fd_sc_mcu7t5v0__fillcap_4
XFILLER_58_691 VDD VDD VSS VSS gf180mcu_fd_sc_mcu7t5v0__fill_2
XFILLER_18_555 VDD VDD VSS VSS gf180mcu_fd_sc_mcu7t5v0__fillcap_4
XTAP_TAPCELL_ROW_63_807 VDD VSS gf180mcu_fd_sc_mcu7t5v0__filltie
XFILLER_45_363 VDD VDD VSS VSS gf180mcu_fd_sc_mcu7t5v0__fillcap_8
XFILLER_45_352 VDD VDD VSS VSS gf180mcu_fd_sc_mcu7t5v0__fillcap_4
XFILLER_72_160 VDD VDD VSS VSS gf180mcu_fd_sc_mcu7t5v0__fill_1
X_1990_ _1990_/D _2127_/RN _2020_/CLK _1990_/Q VDD VDD VSS VSS gf180mcu_fd_sc_mcu7t5v0__dffrnq_1
XFILLER_72_193 VDD VDD VSS VSS gf180mcu_fd_sc_mcu7t5v0__fillcap_4
XFILLER_54_92 VDD VDD VSS VSS gf180mcu_fd_sc_mcu7t5v0__fillcap_4
X_0941_ _2169_/Q _1281_/A1 VDD VDD VSS VSS gf180mcu_fd_sc_mcu7t5v0__clkinv_1
XTAP_TAPCELL_ROW_71_884 VDD VSS gf180mcu_fd_sc_mcu7t5v0__filltie
XFILLER_9_264 VDD VDD VSS VSS gf180mcu_fd_sc_mcu7t5v0__fill_2
Xclkload12 _1887_/CLK clkload12/Z VDD VDD VSS VSS gf180mcu_fd_sc_mcu7t5v0__clkbuf_2
XFILLER_5_492 VDD VDD VSS VSS gf180mcu_fd_sc_mcu7t5v0__fillcap_8
XFILLER_48_2 VDD VDD VSS VSS gf180mcu_fd_sc_mcu7t5v0__fill_2
X_1424_ _1424_/A1 _1172_/B _1054_/Z _2153_/D _1425_/S VDD VDD VSS VSS gf180mcu_fd_sc_mcu7t5v0__nor4_2
XFILLER_68_400 VDD VDD VSS VSS gf180mcu_fd_sc_mcu7t5v0__fillcap_16
X_1355_ _1355_/A1 _1355_/A2 _1355_/A3 _1355_/A4 _1355_/Z VDD VDD VSS VSS gf180mcu_fd_sc_mcu7t5v0__and4_1
XTAP_TAPCELL_ROW_79_962 VDD VSS gf180mcu_fd_sc_mcu7t5v0__filltie
XFILLER_83_414 VDD VDD VSS VSS gf180mcu_fd_sc_mcu7t5v0__fillcap_4
X_1286_ _1294_/A1 _1284_/Z _1286_/A3 _1294_/A4 _2171_/D VDD VDD VSS VSS gf180mcu_fd_sc_mcu7t5v0__and4_1
XTAP_TAPCELL_ROW_87_1039 VDD VSS gf180mcu_fd_sc_mcu7t5v0__filltie
XFILLER_24_503 VDD VDD VSS VSS gf180mcu_fd_sc_mcu7t5v0__fillcap_4
XFILLER_83_469 VDD VDD VSS VSS gf180mcu_fd_sc_mcu7t5v0__fillcap_16
XFILLER_64_661 VDD VDD VSS VSS gf180mcu_fd_sc_mcu7t5v0__fillcap_4
XFILLER_34_18 VDD VDD VSS VSS gf180mcu_fd_sc_mcu7t5v0__fillcap_4
XFILLER_64_683 VDD VDD VSS VSS gf180mcu_fd_sc_mcu7t5v0__fillcap_8
XTAP_TAPCELL_ROW_34_531 VDD VSS gf180mcu_fd_sc_mcu7t5v0__filltie
XPHY_EDGE_ROW_90_Left_189 VDD VSS gf180mcu_fd_sc_mcu7t5v0__endcap
XFILLER_51_366 VDD VDD VSS VSS gf180mcu_fd_sc_mcu7t5v0__fillcap_16
Xclkload6 clkload6/I clkload6/Z VDD VDD VSS VSS gf180mcu_fd_sc_mcu7t5v0__clkbuf_2
XTAP_TAPCELL_ROW_98_1146 VDD VSS gf180mcu_fd_sc_mcu7t5v0__filltie
XTAP_TAPCELL_ROW_98_1157 VDD VSS gf180mcu_fd_sc_mcu7t5v0__filltie
XFILLER_59_422 VDD VDD VSS VSS gf180mcu_fd_sc_mcu7t5v0__fillcap_8
XTAP_TAPCELL_ROW_6_267 VDD VSS gf180mcu_fd_sc_mcu7t5v0__filltie
XFILLER_86_241 VDD VDD VSS VSS gf180mcu_fd_sc_mcu7t5v0__fillcap_4
XFILLER_75_36 VDD VDD VSS VSS gf180mcu_fd_sc_mcu7t5v0__fillcap_32
XFILLER_59_488 VDD VDD VSS VSS gf180mcu_fd_sc_mcu7t5v0__fill_2
XFILLER_47_628 VDD VDD VSS VSS gf180mcu_fd_sc_mcu7t5v0__fill_2
XFILLER_82_491 VDD VDD VSS VSS gf180mcu_fd_sc_mcu7t5v0__fillcap_4
XFILLER_54_193 VDD VDD VSS VSS gf180mcu_fd_sc_mcu7t5v0__fill_1
XFILLER_24_84 VDD VDD VSS VSS gf180mcu_fd_sc_mcu7t5v0__fillcap_16
XFILLER_30_539 VDD VDD VSS VSS gf180mcu_fd_sc_mcu7t5v0__fill_2
XFILLER_10_241 VDD VDD VSS VSS gf180mcu_fd_sc_mcu7t5v0__fillcap_4
XTAP_TAPCELL_ROW_40_589 VDD VSS gf180mcu_fd_sc_mcu7t5v0__filltie
XFILLER_97_506 VDD VDD VSS VSS gf180mcu_fd_sc_mcu7t5v0__fillcap_32
X_1140_ _1140_/A1 _1140_/A2 _1143_/A2 VDD VDD VSS VSS gf180mcu_fd_sc_mcu7t5v0__nor2_1
XTAP_TAPCELL_ROW_76_932 VDD VSS gf180mcu_fd_sc_mcu7t5v0__filltie
X_1071_ _2088_/Q _2164_/Q _1073_/A1 VDD VDD VSS VSS gf180mcu_fd_sc_mcu7t5v0__nand2_1
XTAP_TAPCELL_ROW_48_667 VDD VSS gf180mcu_fd_sc_mcu7t5v0__filltie
XFILLER_52_119 VDD VDD VSS VSS gf180mcu_fd_sc_mcu7t5v0__fill_2
XFILLER_61_664 VDD VDD VSS VSS gf180mcu_fd_sc_mcu7t5v0__fillcap_16
X_1973_ _1973_/D _2092_/RN clkload7/I _1973_/Q VDD VDD VSS VSS gf180mcu_fd_sc_mcu7t5v0__dffrnq_1
X_0924_ _2094_/Q _1138_/B1 VDD VDD VSS VSS gf180mcu_fd_sc_mcu7t5v0__clkinv_1
XTAP_TAPCELL_ROW_93_1098 VDD VSS gf180mcu_fd_sc_mcu7t5v0__filltie
X_1407_ _1856_/Q _2056_/Q _1412_/S _1856_/D VDD VDD VSS VSS gf180mcu_fd_sc_mcu7t5v0__mux2_2
XFILLER_68_263 VDD VDD VSS VSS gf180mcu_fd_sc_mcu7t5v0__fillcap_4
XFILLER_56_403 VDD VDD VSS VSS gf180mcu_fd_sc_mcu7t5v0__fill_1
X_1338_ _1583_/A4 _1338_/A2 _1338_/A3 input5/Z _1350_/C2 VDD VDD VSS VSS gf180mcu_fd_sc_mcu7t5v0__nor4_1
XTAP_TAPCELL_ROW_3_237 VDD VSS gf180mcu_fd_sc_mcu7t5v0__filltie
XFILLER_83_222 VDD VDD VSS VSS gf180mcu_fd_sc_mcu7t5v0__fill_1
X_1269_ _1274_/A1 _1274_/A3 _1272_/A2 VDD VDD VSS VSS gf180mcu_fd_sc_mcu7t5v0__nand2_1
XFILLER_71_406 VDD VDD VSS VSS gf180mcu_fd_sc_mcu7t5v0__fill_1
XFILLER_24_311 VDD VDD VSS VSS gf180mcu_fd_sc_mcu7t5v0__fillcap_4
XFILLER_83_288 VDD VDD VSS VSS gf180mcu_fd_sc_mcu7t5v0__fill_1
XFILLER_71_417 VDD VDD VSS VSS gf180mcu_fd_sc_mcu7t5v0__fill_2
XFILLER_43_119 VDD VDD VSS VSS gf180mcu_fd_sc_mcu7t5v0__fillcap_16
XTAP_TAPCELL_ROW_19_391 VDD VSS gf180mcu_fd_sc_mcu7t5v0__filltie
XFILLER_24_366 VDD VDD VSS VSS gf180mcu_fd_sc_mcu7t5v0__fill_1
XFILLER_52_675 VDD VDD VSS VSS gf180mcu_fd_sc_mcu7t5v0__fillcap_4
XFILLER_51_152 VDD VDD VSS VSS gf180mcu_fd_sc_mcu7t5v0__fillcap_4
XFILLER_51_196 VDD VDD VSS VSS gf180mcu_fd_sc_mcu7t5v0__fillcap_8
XFILLER_79_517 VDD VDD VSS VSS gf180mcu_fd_sc_mcu7t5v0__fillcap_8
XFILLER_19_51 VDD VDD VSS VSS gf180mcu_fd_sc_mcu7t5v0__fillcap_16
XTAP_TAPCELL_ROW_73_902 VDD VSS gf180mcu_fd_sc_mcu7t5v0__filltie
XFILLER_74_233 VDD VDD VSS VSS gf180mcu_fd_sc_mcu7t5v0__fillcap_4
XFILLER_15_300 VDD VDD VSS VSS gf180mcu_fd_sc_mcu7t5v0__fillcap_8
XTAP_TAPCELL_ROW_45_637 VDD VSS gf180mcu_fd_sc_mcu7t5v0__filltie
XFILLER_35_72 VDD VDD VSS VSS gf180mcu_fd_sc_mcu7t5v0__fillcap_64
XFILLER_30_358 VDD VDD VSS VSS gf180mcu_fd_sc_mcu7t5v0__fillcap_16
XFILLER_7_532 VDD VDD VSS VSS gf180mcu_fd_sc_mcu7t5v0__fill_2
X_2172_ _2172_/D _2172_/RN _2172_/CLK _2172_/Q VDD VDD VSS VSS gf180mcu_fd_sc_mcu7t5v0__dffrnq_1
X_1123_ _2096_/Q _2171_/Q _1157_/C1 VDD VDD VSS VSS gf180mcu_fd_sc_mcu7t5v0__nor2_1
XTAP_TAPCELL_ROW_0_207 VDD VSS gf180mcu_fd_sc_mcu7t5v0__filltie
XFILLER_65_255 VDD VDD VSS VSS gf180mcu_fd_sc_mcu7t5v0__fillcap_16
X_1054_ _2151_/D _2150_/D _1054_/Z VDD VDD VSS VSS gf180mcu_fd_sc_mcu7t5v0__and2_1
XTAP_TAPCELL_ROW_84_1009 VDD VSS gf180mcu_fd_sc_mcu7t5v0__filltie
XFILLER_18_193 VDD VDD VSS VSS gf180mcu_fd_sc_mcu7t5v0__fillcap_4
XFILLER_80_247 VDD VDD VSS VSS gf180mcu_fd_sc_mcu7t5v0__fillcap_16
XFILLER_80_269 VDD VDD VSS VSS gf180mcu_fd_sc_mcu7t5v0__fill_1
XTAP_TAPCELL_ROW_16_361 VDD VSS gf180mcu_fd_sc_mcu7t5v0__filltie
X_1956_ _1956_/D _1957_/RN _2000_/CLK _1956_/Q VDD VDD VSS VSS gf180mcu_fd_sc_mcu7t5v0__dffrnq_1
X_0907_ _0907_/I _1604_/A4 VDD VDD VSS VSS gf180mcu_fd_sc_mcu7t5v0__clkinv_1
X_1887_ _1887_/D _1887_/RN _1887_/CLK _1887_/Q VDD VDD VSS VSS gf180mcu_fd_sc_mcu7t5v0__dffrnq_1
XTAP_TAPCELL_ROW_95_1116 VDD VSS gf180mcu_fd_sc_mcu7t5v0__filltie
XFILLER_88_314 VDD VDD VSS VSS gf180mcu_fd_sc_mcu7t5v0__fill_1
Xinput108 data_tx_i[6] _1575_/I0 VDD VDD VSS VSS gf180mcu_fd_sc_mcu7t5v0__dlyb_1
XFILLER_88_358 VDD VDD VSS VSS gf180mcu_fd_sc_mcu7t5v0__fillcap_16
XFILLER_69_572 VDD VDD VSS VSS gf180mcu_fd_sc_mcu7t5v0__fill_1
XFILLER_29_414 VDD VDD VSS VSS gf180mcu_fd_sc_mcu7t5v0__fillcap_4
XFILLER_56_244 VDD VDD VSS VSS gf180mcu_fd_sc_mcu7t5v0__fill_1
XFILLER_16_119 VDD VDD VSS VSS gf180mcu_fd_sc_mcu7t5v0__fill_2
XFILLER_84_597 VDD VDD VSS VSS gf180mcu_fd_sc_mcu7t5v0__fill_2
XFILLER_71_214 VDD VDD VSS VSS gf180mcu_fd_sc_mcu7t5v0__fill_1
XFILLER_71_203 VDD VDD VSS VSS gf180mcu_fd_sc_mcu7t5v0__fillcap_4
XFILLER_56_277 VDD VDD VSS VSS gf180mcu_fd_sc_mcu7t5v0__fillcap_32
XTAP_TAPCELL_ROW_42_607 VDD VSS gf180mcu_fd_sc_mcu7t5v0__filltie
XFILLER_72_37 VDD VDD VSS VSS gf180mcu_fd_sc_mcu7t5v0__fillcap_8
XFILLER_52_461 VDD VDD VSS VSS gf180mcu_fd_sc_mcu7t5v0__fill_1
Xclkbuf_5_22__f_periph_clk_i clkbuf_4_11_0_periph_clk_i/Z _2133_/CLK VDD VDD VSS VSS
+ gf180mcu_fd_sc_mcu7t5v0__clkbuf_16
XFILLER_40_667 VDD VDD VSS VSS gf180mcu_fd_sc_mcu7t5v0__fill_2
XTAP_TAPCELL_ROW_50_684 VDD VSS gf180mcu_fd_sc_mcu7t5v0__filltie
XFILLER_4_524 VDD VDD VSS VSS gf180mcu_fd_sc_mcu7t5v0__fill_1
XFILLER_79_347 VDD VDD VSS VSS gf180mcu_fd_sc_mcu7t5v0__fill_2
XFILLER_94_317 VDD VDD VSS VSS gf180mcu_fd_sc_mcu7t5v0__fillcap_16
XTAP_TAPCELL_ROW_58_762 VDD VSS gf180mcu_fd_sc_mcu7t5v0__filltie
XFILLER_62_247 VDD VDD VSS VSS gf180mcu_fd_sc_mcu7t5v0__fillcap_16
XFILLER_62_225 VDD VDD VSS VSS gf180mcu_fd_sc_mcu7t5v0__fill_2
XFILLER_43_450 VDD VDD VSS VSS gf180mcu_fd_sc_mcu7t5v0__fillcap_4
X_1810_ _2077_/Q _1810_/A2 _1817_/B VDD VDD VSS VSS gf180mcu_fd_sc_mcu7t5v0__nand2_1
XFILLER_30_177 VDD VDD VSS VSS gf180mcu_fd_sc_mcu7t5v0__fillcap_8
XFILLER_11_391 VDD VDD VSS VSS gf180mcu_fd_sc_mcu7t5v0__fillcap_8
X_1741_ _2109_/D _1832_/A2 _1742_/B VDD VDD VSS VSS gf180mcu_fd_sc_mcu7t5v0__and2_1
X_1672_ _2040_/Q input32/Z _1672_/S _2040_/D VDD VDD VSS VSS gf180mcu_fd_sc_mcu7t5v0__mux2_2
Xwire293 wire293/I data_rx_o[0] VDD VDD VSS VSS gf180mcu_fd_sc_mcu7t5v0__clkbuf_3
XFILLER_7_362 VDD VDD VSS VSS gf180mcu_fd_sc_mcu7t5v0__fill_1
XFILLER_98_656 VDD VDD VSS VSS gf180mcu_fd_sc_mcu7t5v0__fillcap_16
XFILLER_98_645 VDD VDD VSS VSS gf180mcu_fd_sc_mcu7t5v0__fill_1
XFILLER_98_634 VDD VDD VSS VSS gf180mcu_fd_sc_mcu7t5v0__fill_1
Xload_slew254 _1421_/S _1423_/S VDD VDD VSS VSS gf180mcu_fd_sc_mcu7t5v0__buf_2
XTAP_TAPCELL_ROW_90_1068 VDD VSS gf180mcu_fd_sc_mcu7t5v0__filltie
XFILLER_58_509 VDD VDD VSS VSS gf180mcu_fd_sc_mcu7t5v0__fillcap_16
Xclkbuf_5_14__f_sys_clk_i clkbuf_4_7_0_sys_clk_i/Z _2116_/CLK VDD VDD VSS VSS gf180mcu_fd_sc_mcu7t5v0__clkbuf_16
XFILLER_85_328 VDD VDD VSS VSS gf180mcu_fd_sc_mcu7t5v0__fillcap_4
XFILLER_66_520 VDD VDD VSS VSS gf180mcu_fd_sc_mcu7t5v0__fillcap_4
X_2155_ _2155_/D _2155_/RN _2155_/CLK _2155_/Q VDD VDD VSS VSS gf180mcu_fd_sc_mcu7t5v0__dffrnq_1
XFILLER_66_553 VDD VDD VSS VSS gf180mcu_fd_sc_mcu7t5v0__fill_1
XFILLER_38_255 VDD VDD VSS VSS gf180mcu_fd_sc_mcu7t5v0__fillcap_8
X_1106_ _1102_/Z _1106_/A2 _1104_/Z _1106_/B2 _1108_/A4 VDD VDD VSS VSS gf180mcu_fd_sc_mcu7t5v0__aoi22_1
XFILLER_53_214 VDD VDD VSS VSS gf180mcu_fd_sc_mcu7t5v0__fill_1
X_2086_ _2086_/D _2098_/RN _2133_/CLK _2086_/Q VDD VDD VSS VSS gf180mcu_fd_sc_mcu7t5v0__dffrnq_1
XFILLER_81_556 VDD VDD VSS VSS gf180mcu_fd_sc_mcu7t5v0__fillcap_4
XFILLER_81_545 VDD VDD VSS VSS gf180mcu_fd_sc_mcu7t5v0__fillcap_4
XFILLER_38_299 VDD VDD VSS VSS gf180mcu_fd_sc_mcu7t5v0__fillcap_16
X_1037_ _1025_/Z _1029_/Z _1030_/Z _1036_/Z _1039_/A3 VDD VDD VSS VSS gf180mcu_fd_sc_mcu7t5v0__nor4_1
XFILLER_21_166 VDD VDD VSS VSS gf180mcu_fd_sc_mcu7t5v0__fillcap_4
X_1939_ _1939_/D _1948_/RN _1952_/CLK _1939_/Q VDD VDD VSS VSS gf180mcu_fd_sc_mcu7t5v0__dffrnq_1
Xinput90 cfg_tx_curr_addr_i[3] input90/Z VDD VDD VSS VSS gf180mcu_fd_sc_mcu7t5v0__dlyb_1
Xmax_cap560 _2079_/RN _2082_/RN VDD VDD VSS VSS gf180mcu_fd_sc_mcu7t5v0__buf_2
XFILLER_88_177 VDD VDD VSS VSS gf180mcu_fd_sc_mcu7t5v0__fillcap_64
XFILLER_29_244 VDD VDD VSS VSS gf180mcu_fd_sc_mcu7t5v0__fillcap_16
XFILLER_17_417 VDD VDD VSS VSS gf180mcu_fd_sc_mcu7t5v0__fill_2
XTAP_TAPCELL_ROW_55_732 VDD VSS gf180mcu_fd_sc_mcu7t5v0__filltie
XFILLER_84_383 VDD VDD VSS VSS gf180mcu_fd_sc_mcu7t5v0__fill_2
XFILLER_44_247 VDD VDD VSS VSS gf180mcu_fd_sc_mcu7t5v0__fillcap_8
XTAP_TAPCELL_ROW_27_467 VDD VSS gf180mcu_fd_sc_mcu7t5v0__filltie
XPHY_EDGE_ROW_11_Right_11 VDD VSS gf180mcu_fd_sc_mcu7t5v0__endcap
XFILLER_52_280 VDD VDD VSS VSS gf180mcu_fd_sc_mcu7t5v0__fillcap_4
XFILLER_8_104 VDD VDD VSS VSS gf180mcu_fd_sc_mcu7t5v0__fill_1
XFILLER_40_475 VDD VDD VSS VSS gf180mcu_fd_sc_mcu7t5v0__fill_1
XTAP_TAPCELL_ROW_10_312 VDD VSS gf180mcu_fd_sc_mcu7t5v0__filltie
XPHY_EDGE_ROW_20_Right_20 VDD VSS gf180mcu_fd_sc_mcu7t5v0__endcap
XFILLER_4_387 VDD VDD VSS VSS gf180mcu_fd_sc_mcu7t5v0__fillcap_32
XFILLER_67_306 VDD VDD VSS VSS gf180mcu_fd_sc_mcu7t5v0__fillcap_4
XFILLER_95_626 VDD VDD VSS VSS gf180mcu_fd_sc_mcu7t5v0__fillcap_4
XFILLER_79_199 VDD VDD VSS VSS gf180mcu_fd_sc_mcu7t5v0__fillcap_8
XFILLER_48_520 VDD VDD VSS VSS gf180mcu_fd_sc_mcu7t5v0__fillcap_4
XFILLER_48_597 VDD VDD VSS VSS gf180mcu_fd_sc_mcu7t5v0__fillcap_16
XFILLER_35_236 VDD VDD VSS VSS gf180mcu_fd_sc_mcu7t5v0__fillcap_4
XFILLER_50_206 VDD VDD VSS VSS gf180mcu_fd_sc_mcu7t5v0__fill_1
XFILLER_78_2 VDD VDD VSS VSS gf180mcu_fd_sc_mcu7t5v0__fillcap_32
X_1724_ _1739_/A1 _1718_/S _1724_/A3 _1724_/B _2063_/D VDD VDD VSS VSS gf180mcu_fd_sc_mcu7t5v0__oai31_1
XFILLER_8_693 VDD VDD VSS VSS gf180mcu_fd_sc_mcu7t5v0__fill_1
X_1655_ _2025_/Q input34/Z _1662_/S _2025_/D VDD VDD VSS VSS gf180mcu_fd_sc_mcu7t5v0__mux2_2
X_1586_ _1960_/Q input13/Z _1601_/S _1960_/D VDD VDD VSS VSS gf180mcu_fd_sc_mcu7t5v0__mux2_2
XFILLER_58_317 VDD VDD VSS VSS gf180mcu_fd_sc_mcu7t5v0__fill_2
XTAP_TAPCELL_ROW_69_868 VDD VSS gf180mcu_fd_sc_mcu7t5v0__filltie
XFILLER_85_136 VDD VDD VSS VSS gf180mcu_fd_sc_mcu7t5v0__fillcap_4
XFILLER_66_372 VDD VDD VSS VSS gf180mcu_fd_sc_mcu7t5v0__fillcap_8
X_2138_ _2138_/D _2139_/RN _2138_/CLK _2138_/Q VDD VDD VSS VSS gf180mcu_fd_sc_mcu7t5v0__dffrnq_1
XFILLER_26_247 VDD VDD VSS VSS gf180mcu_fd_sc_mcu7t5v0__fill_2
X_2069_ _2069_/D _2082_/RN _2157_/CLK _2069_/Q VDD VDD VSS VSS gf180mcu_fd_sc_mcu7t5v0__dffrnq_1
XTAP_TAPCELL_ROW_52_702 VDD VSS gf180mcu_fd_sc_mcu7t5v0__filltie
XFILLER_22_453 VDD VDD VSS VSS gf180mcu_fd_sc_mcu7t5v0__fill_2
XTAP_TAPCELL_ROW_24_437 VDD VSS gf180mcu_fd_sc_mcu7t5v0__filltie
XFILLER_89_442 VDD VDD VSS VSS gf180mcu_fd_sc_mcu7t5v0__fill_1
XFILLER_49_306 VDD VDD VSS VSS gf180mcu_fd_sc_mcu7t5v0__fillcap_4
XFILLER_49_317 VDD VDD VSS VSS gf180mcu_fd_sc_mcu7t5v0__fillcap_16
XFILLER_17_203 VDD VDD VSS VSS gf180mcu_fd_sc_mcu7t5v0__fill_1
XFILLER_85_692 VDD VDD VSS VSS gf180mcu_fd_sc_mcu7t5v0__fill_2
XFILLER_27_84 VDD VDD VSS VSS gf180mcu_fd_sc_mcu7t5v0__fillcap_8
XFILLER_72_353 VDD VDD VSS VSS gf180mcu_fd_sc_mcu7t5v0__fillcap_8
XFILLER_13_464 VDD VDD VSS VSS gf180mcu_fd_sc_mcu7t5v0__fillcap_16
Xoutput209 _1307_/Z wire291/I VDD VDD VSS VSS gf180mcu_fd_sc_mcu7t5v0__buf_1
X_1440_ _2062_/Q _1886_/Q _1440_/S _1886_/D VDD VDD VSS VSS gf180mcu_fd_sc_mcu7t5v0__mux2_2
X_1371_ _2040_/Q _1179_/Z _1395_/A2 input79/Z _1372_/A3 VDD VDD VSS VSS gf180mcu_fd_sc_mcu7t5v0__aoi22_1
XFILLER_67_136 VDD VDD VSS VSS gf180mcu_fd_sc_mcu7t5v0__fillcap_4
XFILLER_36_523 VDD VDD VSS VSS gf180mcu_fd_sc_mcu7t5v0__fill_2
XTAP_TAPCELL_ROW_66_838 VDD VSS gf180mcu_fd_sc_mcu7t5v0__filltie
XFILLER_63_386 VDD VDD VSS VSS gf180mcu_fd_sc_mcu7t5v0__fillcap_4
XFILLER_51_559 VDD VDD VSS VSS gf180mcu_fd_sc_mcu7t5v0__fill_1
X_1707_ _2057_/Q _2056_/Q _1708_/S _2056_/D VDD VDD VSS VSS gf180mcu_fd_sc_mcu7t5v0__mux2_2
X_1638_ _2009_/Q input28/Z _1641_/S _2009_/D VDD VDD VSS VSS gf180mcu_fd_sc_mcu7t5v0__mux2_2
X_1569_ _1569_/I0 _1948_/Q _1571_/S _1948_/D VDD VDD VSS VSS gf180mcu_fd_sc_mcu7t5v0__mux2_2
Xfanout425 _1604_/A3 _1195_/A4 VDD VDD VSS VSS gf180mcu_fd_sc_mcu7t5v0__dlyb_1
Xfanout436 _2033_/RN _1999_/RN VDD VDD VSS VSS gf180mcu_fd_sc_mcu7t5v0__dlyb_1
Xfanout458 input111/Z fanout458/Z VDD VDD VSS VSS gf180mcu_fd_sc_mcu7t5v0__dlyb_1
Xfanout469 _2176_/RN _1926_/RN VDD VDD VSS VSS gf180mcu_fd_sc_mcu7t5v0__dlyb_1
XFILLER_67_692 VDD VDD VSS VSS gf180mcu_fd_sc_mcu7t5v0__fill_2
XFILLER_54_331 VDD VDD VSS VSS gf180mcu_fd_sc_mcu7t5v0__fillcap_4
XTAP_TAPCELL_ROW_37_562 VDD VSS gf180mcu_fd_sc_mcu7t5v0__filltie
XFILLER_80_37 VDD VDD VSS VSS gf180mcu_fd_sc_mcu7t5v0__fillcap_8
XFILLER_6_405 VDD VDD VSS VSS gf180mcu_fd_sc_mcu7t5v0__fill_1
XFILLER_8_2 VDD VDD VSS VSS gf180mcu_fd_sc_mcu7t5v0__fillcap_32
XTAP_TAPCELL_ROW_9_298 VDD VSS gf180mcu_fd_sc_mcu7t5v0__filltie
XFILLER_77_401 VDD VDD VSS VSS gf180mcu_fd_sc_mcu7t5v0__fillcap_16
XTAP_TAPCELL_ROW_63_808 VDD VSS gf180mcu_fd_sc_mcu7t5v0__filltie
XFILLER_72_150 VDD VDD VSS VSS gf180mcu_fd_sc_mcu7t5v0__fillcap_8
Xclkbuf_5_2__f_sys_clk_i clkbuf_4_1_0_sys_clk_i/Z _2025_/CLK VDD VDD VSS VSS gf180mcu_fd_sc_mcu7t5v0__clkbuf_16
XFILLER_13_261 VDD VDD VSS VSS gf180mcu_fd_sc_mcu7t5v0__fill_2
X_0940_ _2168_/Q _1280_/A1 VDD VDD VSS VSS gf180mcu_fd_sc_mcu7t5v0__clkinv_1
XTAP_TAPCELL_ROW_71_885 VDD VSS gf180mcu_fd_sc_mcu7t5v0__filltie
Xclkload13 _2058_/CLK clkload13/Z VDD VDD VSS VSS gf180mcu_fd_sc_mcu7t5v0__clkbuf_2
X_1423_ _2063_/Q _1871_/Q _1423_/S _1871_/D VDD VDD VSS VSS gf180mcu_fd_sc_mcu7t5v0__mux2_2
X_1354_ _2038_/Q _1354_/A2 _1354_/A3 _1329_/Z _1355_/A4 VDD VDD VSS VSS gf180mcu_fd_sc_mcu7t5v0__nand4_1
X_1285_ _2169_/Q _2170_/Q _2171_/Q _1300_/A2 _1286_/A3 VDD VDD VSS VSS gf180mcu_fd_sc_mcu7t5v0__nand4_1
XTAP_TAPCELL_ROW_79_963 VDD VSS gf180mcu_fd_sc_mcu7t5v0__filltie
XFILLER_95_286 VDD VDD VSS VSS gf180mcu_fd_sc_mcu7t5v0__fill_2
XFILLER_55_139 VDD VDD VSS VSS gf180mcu_fd_sc_mcu7t5v0__fill_1
XTAP_TAPCELL_ROW_34_532 VDD VSS gf180mcu_fd_sc_mcu7t5v0__filltie
XFILLER_91_492 VDD VDD VSS VSS gf180mcu_fd_sc_mcu7t5v0__fillcap_32
Xclkload7 clkload7/I clkload7/Z VDD VDD VSS VSS gf180mcu_fd_sc_mcu7t5v0__clkbuf_2
XTAP_TAPCELL_ROW_98_1158 VDD VSS gf180mcu_fd_sc_mcu7t5v0__filltie
XTAP_TAPCELL_ROW_98_1147 VDD VSS gf180mcu_fd_sc_mcu7t5v0__filltie
XFILLER_3_408 VDD VDD VSS VSS gf180mcu_fd_sc_mcu7t5v0__fill_2
XFILLER_59_16 VDD VDD VSS VSS gf180mcu_fd_sc_mcu7t5v0__fillcap_4
Xfanout222 _1304_/A1 _1294_/A1 VDD VDD VSS VSS gf180mcu_fd_sc_mcu7t5v0__dlyb_1
XTAP_TAPCELL_ROW_6_268 VDD VSS gf180mcu_fd_sc_mcu7t5v0__filltie
XFILLER_86_297 VDD VDD VSS VSS gf180mcu_fd_sc_mcu7t5v0__fillcap_16
XFILLER_74_448 VDD VDD VSS VSS gf180mcu_fd_sc_mcu7t5v0__fillcap_4
XFILLER_70_621 VDD VDD VSS VSS gf180mcu_fd_sc_mcu7t5v0__fill_2
XFILLER_54_172 VDD VDD VSS VSS gf180mcu_fd_sc_mcu7t5v0__fill_2
XFILLER_15_548 VDD VDD VSS VSS gf180mcu_fd_sc_mcu7t5v0__fillcap_4
XFILLER_37_106 VDD VDD VSS VSS gf180mcu_fd_sc_mcu7t5v0__fill_1
XFILLER_1_34 VDD VDD VSS VSS gf180mcu_fd_sc_mcu7t5v0__fillcap_16
XTAP_TAPCELL_ROW_76_933 VDD VSS gf180mcu_fd_sc_mcu7t5v0__filltie
Xclkbuf_5_19__f_sys_clk_i clkbuf_4_9_0_sys_clk_i/Z clkload4/I VDD VDD VSS VSS gf180mcu_fd_sc_mcu7t5v0__clkbuf_16
X_1070_ _1068_/Z _1070_/A2 _1075_/A2 VDD VDD VSS VSS gf180mcu_fd_sc_mcu7t5v0__nand2_1
XTAP_TAPCELL_ROW_48_668 VDD VSS gf180mcu_fd_sc_mcu7t5v0__filltie
XFILLER_45_150 VDD VDD VSS VSS gf180mcu_fd_sc_mcu7t5v0__fill_1
XFILLER_73_492 VDD VDD VSS VSS gf180mcu_fd_sc_mcu7t5v0__fillcap_16
XFILLER_61_632 VDD VDD VSS VSS gf180mcu_fd_sc_mcu7t5v0__fillcap_32
XFILLER_21_529 VDD VDD VSS VSS gf180mcu_fd_sc_mcu7t5v0__fillcap_16
X_1972_ _1972_/D _2174_/RN _1975_/CLK _1972_/Q VDD VDD VSS VSS gf180mcu_fd_sc_mcu7t5v0__dffrnq_1
X_0923_ _2093_/Q _1154_/A1 VDD VDD VSS VSS gf180mcu_fd_sc_mcu7t5v0__clkinv_1
XFILLER_60_2 VDD VDD VSS VSS gf180mcu_fd_sc_mcu7t5v0__fill_2
XPHY_EDGE_ROW_49_Right_49 VDD VSS gf180mcu_fd_sc_mcu7t5v0__endcap
XTAP_TAPCELL_ROW_93_1099 VDD VSS gf180mcu_fd_sc_mcu7t5v0__filltie
XFILLER_88_529 VDD VDD VSS VSS gf180mcu_fd_sc_mcu7t5v0__fill_1
X_1406_ _1415_/A1 _1406_/A2 _1415_/A3 _1415_/A4 _1412_/S VDD VDD VSS VSS gf180mcu_fd_sc_mcu7t5v0__and4_1
X_1337_ input1/Z _1673_/A2 _1338_/A3 VDD VDD VSS VSS gf180mcu_fd_sc_mcu7t5v0__nand2_1
XTAP_TAPCELL_ROW_3_238 VDD VSS gf180mcu_fd_sc_mcu7t5v0__filltie
XFILLER_83_212 VDD VDD VSS VSS gf180mcu_fd_sc_mcu7t5v0__fillcap_8
XFILLER_68_297 VDD VDD VSS VSS gf180mcu_fd_sc_mcu7t5v0__fillcap_4
Xclkbuf_5_30__f_periph_clk_i clkbuf_4_15_0_periph_clk_i/Z _2173_/CLK VDD VDD VSS VSS
+ gf180mcu_fd_sc_mcu7t5v0__clkbuf_16
X_1268_ _1294_/A1 _1274_/A3 _1268_/A3 _1294_/A4 _2166_/D VDD VDD VSS VSS gf180mcu_fd_sc_mcu7t5v0__and4_1
XPHY_EDGE_ROW_58_Right_58 VDD VSS gf180mcu_fd_sc_mcu7t5v0__endcap
X_1199_ _2130_/Q _2131_/Q _1199_/Z VDD VDD VSS VSS gf180mcu_fd_sc_mcu7t5v0__and2_1
XTAP_TAPCELL_ROW_19_392 VDD VSS gf180mcu_fd_sc_mcu7t5v0__filltie
XFILLER_12_518 VDD VDD VSS VSS gf180mcu_fd_sc_mcu7t5v0__fillcap_4
XFILLER_51_142 VDD VDD VSS VSS gf180mcu_fd_sc_mcu7t5v0__fillcap_4
Xclkbuf_5_21__f_sys_clk_i clkbuf_4_10_0_sys_clk_i/Z _1954_/CLK VDD VDD VSS VSS gf180mcu_fd_sc_mcu7t5v0__clkbuf_16
XPHY_EDGE_ROW_67_Right_67 VDD VSS gf180mcu_fd_sc_mcu7t5v0__endcap
XFILLER_3_205 VDD VDD VSS VSS gf180mcu_fd_sc_mcu7t5v0__fillcap_4
XFILLER_87_562 VDD VDD VSS VSS gf180mcu_fd_sc_mcu7t5v0__fillcap_4
XFILLER_47_404 VDD VDD VSS VSS gf180mcu_fd_sc_mcu7t5v0__fillcap_4
XPHY_EDGE_ROW_76_Right_76 VDD VSS gf180mcu_fd_sc_mcu7t5v0__endcap
XTAP_TAPCELL_ROW_73_903 VDD VSS gf180mcu_fd_sc_mcu7t5v0__filltie
XFILLER_28_662 VDD VDD VSS VSS gf180mcu_fd_sc_mcu7t5v0__fill_2
XTAP_TAPCELL_ROW_45_638 VDD VSS gf180mcu_fd_sc_mcu7t5v0__filltie
XFILLER_55_492 VDD VDD VSS VSS gf180mcu_fd_sc_mcu7t5v0__fillcap_16
XFILLER_43_632 VDD VDD VSS VSS gf180mcu_fd_sc_mcu7t5v0__fill_2
XTAP_TAPCELL_ROW_81_980 VDD VSS gf180mcu_fd_sc_mcu7t5v0__filltie
XFILLER_11_562 VDD VDD VSS VSS gf180mcu_fd_sc_mcu7t5v0__fillcap_4
XPHY_EDGE_ROW_85_Right_85 VDD VSS gf180mcu_fd_sc_mcu7t5v0__endcap
XFILLER_51_72 VDD VDD VSS VSS gf180mcu_fd_sc_mcu7t5v0__fillcap_16
Xload_slew447 _2111_/RN _2127_/RN VDD VDD VSS VSS gf180mcu_fd_sc_mcu7t5v0__clkbuf_3
XPHY_EDGE_ROW_94_Right_94 VDD VSS gf180mcu_fd_sc_mcu7t5v0__endcap
X_2171_ _2171_/D _2172_/RN _2171_/CLK _2171_/Q VDD VDD VSS VSS gf180mcu_fd_sc_mcu7t5v0__dffrnq_1
XFILLER_65_212 VDD VDD VSS VSS gf180mcu_fd_sc_mcu7t5v0__fillcap_4
X_1122_ _1270_/A1 _2090_/Q _1139_/A4 VDD VDD VSS VSS gf180mcu_fd_sc_mcu7t5v0__nand2_1
XTAP_TAPCELL_ROW_0_208 VDD VSS gf180mcu_fd_sc_mcu7t5v0__filltie
X_1053_ _1892_/Q _1894_/Q _1895_/Q _1057_/B2 VDD VDD VSS VSS gf180mcu_fd_sc_mcu7t5v0__oai21_1
XFILLER_34_676 VDD VDD VSS VSS gf180mcu_fd_sc_mcu7t5v0__fill_2
XTAP_TAPCELL_ROW_16_362 VDD VSS gf180mcu_fd_sc_mcu7t5v0__filltie
X_1955_ _1955_/D _2190_/RN _1955_/CLK _1955_/Q VDD VDD VSS VSS gf180mcu_fd_sc_mcu7t5v0__dffrnq_1
X_0906_ _0906_/I _1604_/A3 VDD VDD VSS VSS gf180mcu_fd_sc_mcu7t5v0__clkinv_1
X_1886_ _1886_/D _1886_/RN _1887_/CLK _1886_/Q VDD VDD VSS VSS gf180mcu_fd_sc_mcu7t5v0__dffrnq_1
XTAP_TAPCELL_ROW_95_1117 VDD VSS gf180mcu_fd_sc_mcu7t5v0__filltie
Xinput109 data_tx_i[7] _1576_/I0 VDD VDD VSS VSS gf180mcu_fd_sc_mcu7t5v0__dlyb_1
XFILLER_69_562 VDD VDD VSS VSS gf180mcu_fd_sc_mcu7t5v0__fillcap_8
XFILLER_69_540 VDD VDD VSS VSS gf180mcu_fd_sc_mcu7t5v0__fill_2
XFILLER_29_426 VDD VDD VSS VSS gf180mcu_fd_sc_mcu7t5v0__fill_2
XFILLER_56_267 VDD VDD VSS VSS gf180mcu_fd_sc_mcu7t5v0__fill_2
XFILLER_37_492 VDD VDD VSS VSS gf180mcu_fd_sc_mcu7t5v0__fill_2
XFILLER_72_16 VDD VDD VSS VSS gf180mcu_fd_sc_mcu7t5v0__fillcap_4
XTAP_TAPCELL_ROW_42_608 VDD VSS gf180mcu_fd_sc_mcu7t5v0__filltie
XTAP_TAPCELL_ROW_50_685 VDD VSS gf180mcu_fd_sc_mcu7t5v0__filltie
XFILLER_4_547 VDD VDD VSS VSS gf180mcu_fd_sc_mcu7t5v0__fill_2
XTAP_TAPCELL_ROW_58_763 VDD VSS gf180mcu_fd_sc_mcu7t5v0__filltie
XFILLER_90_502 VDD VDD VSS VSS gf180mcu_fd_sc_mcu7t5v0__fillcap_8
XFILLER_90_535 VDD VDD VSS VSS gf180mcu_fd_sc_mcu7t5v0__fill_2
XFILLER_15_142 VDD VDD VSS VSS gf180mcu_fd_sc_mcu7t5v0__fillcap_4
XTAP_TAPCELL_ROW_13_332 VDD VSS gf180mcu_fd_sc_mcu7t5v0__filltie
X_1740_ _1740_/A1 _1740_/A2 _1740_/A3 _1829_/A2 VDD VDD VSS VSS gf180mcu_fd_sc_mcu7t5v0__nand3_1
X_1671_ _1671_/A1 _1671_/A2 _2039_/D VDD VDD VSS VSS gf180mcu_fd_sc_mcu7t5v0__nand2_1
XFILLER_7_66 VDD VDD VSS VSS gf180mcu_fd_sc_mcu7t5v0__fillcap_4
XFILLER_7_352 VDD VDD VSS VSS gf180mcu_fd_sc_mcu7t5v0__fillcap_8
Xwire294 wire294/I cfg_data_o[31] VDD VDD VSS VSS gf180mcu_fd_sc_mcu7t5v0__clkbuf_3
XTAP_TAPCELL_ROW_90_1069 VDD VSS gf180mcu_fd_sc_mcu7t5v0__filltie
XFILLER_38_201 VDD VDD VSS VSS gf180mcu_fd_sc_mcu7t5v0__fill_2
X_2154_ _2154_/D _2156_/RN _2154_/CLK _2154_/Q VDD VDD VSS VSS gf180mcu_fd_sc_mcu7t5v0__dffrnq_1
XFILLER_66_543 VDD VDD VSS VSS gf180mcu_fd_sc_mcu7t5v0__fillcap_8
X_1105_ _2087_/Q _2163_/Q _1106_/B2 VDD VDD VSS VSS gf180mcu_fd_sc_mcu7t5v0__nand2_1
XFILLER_19_481 VDD VDD VSS VSS gf180mcu_fd_sc_mcu7t5v0__fillcap_8
XFILLER_19_492 VDD VDD VSS VSS gf180mcu_fd_sc_mcu7t5v0__fillcap_8
X_2085_ _2085_/D _2130_/RN _2130_/CLK _2085_/Q VDD VDD VSS VSS gf180mcu_fd_sc_mcu7t5v0__dffrnq_1
XFILLER_81_524 VDD VDD VSS VSS gf180mcu_fd_sc_mcu7t5v0__fill_1
X_1036_ _2096_/Q _2141_/Q _1036_/Z VDD VDD VSS VSS gf180mcu_fd_sc_mcu7t5v0__xor2_1
XFILLER_22_657 VDD VDD VSS VSS gf180mcu_fd_sc_mcu7t5v0__fill_1
X_1938_ _1938_/D _1957_/RN _2000_/CLK _1938_/Q VDD VDD VSS VSS gf180mcu_fd_sc_mcu7t5v0__dffrnq_1
X_1869_ _1869_/D _2156_/RN _2182_/CLK _1869_/Q VDD VDD VSS VSS gf180mcu_fd_sc_mcu7t5v0__dffrnq_1
Xinput91 cfg_tx_curr_addr_i[4] input91/Z VDD VDD VSS VSS gf180mcu_fd_sc_mcu7t5v0__dlyb_1
Xinput80 cfg_tx_bytes_left_i[5] input80/Z VDD VDD VSS VSS gf180mcu_fd_sc_mcu7t5v0__dlyb_1
Xmax_cap561 _2047_/RN _2188_/RN VDD VDD VSS VSS gf180mcu_fd_sc_mcu7t5v0__buf_2
Xmax_cap550 _2067_/RN _2081_/RN VDD VDD VSS VSS gf180mcu_fd_sc_mcu7t5v0__buf_2
XFILLER_88_101 VDD VDD VSS VSS gf180mcu_fd_sc_mcu7t5v0__fillcap_4
XFILLER_76_307 VDD VDD VSS VSS gf180mcu_fd_sc_mcu7t5v0__fillcap_8
XFILLER_29_212 VDD VDD VSS VSS gf180mcu_fd_sc_mcu7t5v0__fillcap_32
XFILLER_76_329 VDD VDD VSS VSS gf180mcu_fd_sc_mcu7t5v0__fillcap_16
XFILLER_57_554 VDD VDD VSS VSS gf180mcu_fd_sc_mcu7t5v0__fillcap_4
XFILLER_29_278 VDD VDD VSS VSS gf180mcu_fd_sc_mcu7t5v0__fill_2
XFILLER_72_502 VDD VDD VSS VSS gf180mcu_fd_sc_mcu7t5v0__fillcap_16
XTAP_TAPCELL_ROW_55_733 VDD VSS gf180mcu_fd_sc_mcu7t5v0__filltie
XFILLER_72_524 VDD VDD VSS VSS gf180mcu_fd_sc_mcu7t5v0__fill_1
XFILLER_16_31 VDD VDD VSS VSS gf180mcu_fd_sc_mcu7t5v0__fillcap_4
XTAP_TAPCELL_ROW_27_468 VDD VSS gf180mcu_fd_sc_mcu7t5v0__filltie
XFILLER_12_101 VDD VDD VSS VSS gf180mcu_fd_sc_mcu7t5v0__fillcap_4
XFILLER_12_123 VDD VDD VSS VSS gf180mcu_fd_sc_mcu7t5v0__fillcap_4
Xclkbuf_5_7__f_sys_clk_i clkbuf_4_3_0_sys_clk_i/Z clkload0/I VDD VDD VSS VSS gf180mcu_fd_sc_mcu7t5v0__clkbuf_16
XFILLER_9_628 VDD VDD VSS VSS gf180mcu_fd_sc_mcu7t5v0__fill_2
XFILLER_48_576 VDD VDD VSS VSS gf180mcu_fd_sc_mcu7t5v0__fillcap_16
XFILLER_90_365 VDD VDD VSS VSS gf180mcu_fd_sc_mcu7t5v0__fillcap_4
X_1723_ _1718_/S _2063_/Q _1724_/B VDD VDD VSS VSS gf180mcu_fd_sc_mcu7t5v0__nand2_1
XFILLER_8_683 VDD VDD VSS VSS gf180mcu_fd_sc_mcu7t5v0__fillcap_8
XFILLER_8_661 VDD VDD VSS VSS gf180mcu_fd_sc_mcu7t5v0__fillcap_4
X_1654_ _2024_/Q input33/Z _1662_/S _2024_/D VDD VDD VSS VSS gf180mcu_fd_sc_mcu7t5v0__mux2_2
X_1585_ _1959_/Q input6/Z _1672_/S _1959_/D VDD VDD VSS VSS gf180mcu_fd_sc_mcu7t5v0__mux2_2
XPHY_EDGE_ROW_13_Left_112 VDD VSS gf180mcu_fd_sc_mcu7t5v0__endcap
XTAP_TAPCELL_ROW_69_869 VDD VSS gf180mcu_fd_sc_mcu7t5v0__filltie
XFILLER_54_502 VDD VDD VSS VSS gf180mcu_fd_sc_mcu7t5v0__fillcap_16
X_2137_ _2137_/D _2160_/RN _2138_/CLK _2137_/Q VDD VDD VSS VSS gf180mcu_fd_sc_mcu7t5v0__dffrnq_1
XFILLER_94_693 VDD VDD VSS VSS gf180mcu_fd_sc_mcu7t5v0__fill_1
XFILLER_66_384 VDD VDD VSS VSS gf180mcu_fd_sc_mcu7t5v0__fill_1
XFILLER_54_524 VDD VDD VSS VSS gf180mcu_fd_sc_mcu7t5v0__fill_1
X_2068_ _2068_/D _2108_/RN _2108_/CLK _2068_/Q VDD VDD VSS VSS gf180mcu_fd_sc_mcu7t5v0__dffrnq_1
XFILLER_81_354 VDD VDD VSS VSS gf180mcu_fd_sc_mcu7t5v0__fill_1
X_1019_ _2095_/Q _2140_/Q _1038_/A1 VDD VDD VSS VSS gf180mcu_fd_sc_mcu7t5v0__xnor2_1
XTAP_TAPCELL_ROW_52_703 VDD VSS gf180mcu_fd_sc_mcu7t5v0__filltie
XFILLER_41_207 VDD VDD VSS VSS gf180mcu_fd_sc_mcu7t5v0__fill_2
XTAP_TAPCELL_ROW_24_438 VDD VSS gf180mcu_fd_sc_mcu7t5v0__filltie
XPHY_EDGE_ROW_22_Left_121 VDD VSS gf180mcu_fd_sc_mcu7t5v0__endcap
XFILLER_22_465 VDD VDD VSS VSS gf180mcu_fd_sc_mcu7t5v0__fill_2
XTAP_TAPCELL_ROW_60_780 VDD VSS gf180mcu_fd_sc_mcu7t5v0__filltie
XPHY_EDGE_ROW_31_Left_130 VDD VSS gf180mcu_fd_sc_mcu7t5v0__endcap
XFILLER_78_37 VDD VDD VSS VSS gf180mcu_fd_sc_mcu7t5v0__fillcap_8
XFILLER_1_358 VDD VDD VSS VSS gf180mcu_fd_sc_mcu7t5v0__fill_1
XFILLER_77_627 VDD VDD VSS VSS gf180mcu_fd_sc_mcu7t5v0__fill_2
XFILLER_17_237 VDD VDD VSS VSS gf180mcu_fd_sc_mcu7t5v0__fillcap_4
XFILLER_27_52 VDD VDD VSS VSS gf180mcu_fd_sc_mcu7t5v0__fillcap_16
XFILLER_17_259 VDD VDD VSS VSS gf180mcu_fd_sc_mcu7t5v0__fillcap_4
XFILLER_27_96 VDD VDD VSS VSS gf180mcu_fd_sc_mcu7t5v0__fill_1
XFILLER_60_527 VDD VDD VSS VSS gf180mcu_fd_sc_mcu7t5v0__fillcap_64
XFILLER_13_432 VDD VDD VSS VSS gf180mcu_fd_sc_mcu7t5v0__fillcap_32
XFILLER_9_403 VDD VDD VSS VSS gf180mcu_fd_sc_mcu7t5v0__fill_1
XFILLER_5_664 VDD VDD VSS VSS gf180mcu_fd_sc_mcu7t5v0__fillcap_16
XFILLER_4_34 VDD VDD VSS VSS gf180mcu_fd_sc_mcu7t5v0__fill_1
X_1370_ _2047_/Q _1325_/Z _1396_/A2 input49/Z _1372_/A2 VDD VDD VSS VSS gf180mcu_fd_sc_mcu7t5v0__aoi22_1
XFILLER_4_45 VDD VDD VSS VSS gf180mcu_fd_sc_mcu7t5v0__fill_2
XFILLER_83_608 VDD VDD VSS VSS gf180mcu_fd_sc_mcu7t5v0__fill_1
XFILLER_82_107 VDD VDD VSS VSS gf180mcu_fd_sc_mcu7t5v0__fillcap_16
XTAP_TAPCELL_ROW_89_1060 VDD VSS gf180mcu_fd_sc_mcu7t5v0__filltie
XTAP_TAPCELL_ROW_66_839 VDD VSS gf180mcu_fd_sc_mcu7t5v0__filltie
XFILLER_76_693 VDD VDD VSS VSS gf180mcu_fd_sc_mcu7t5v0__fill_1
XFILLER_23_207 VDD VDD VSS VSS gf180mcu_fd_sc_mcu7t5v0__fill_2
XTAP_TAPCELL_ROW_21_408 VDD VSS gf180mcu_fd_sc_mcu7t5v0__filltie
XFILLER_90_2 VDD VDD VSS VSS gf180mcu_fd_sc_mcu7t5v0__fillcap_32
Xclkbuf_5_26__f_sys_clk_i clkbuf_4_13_0_sys_clk_i/Z _2020_/CLK VDD VDD VSS VSS gf180mcu_fd_sc_mcu7t5v0__clkbuf_16
X_1706_ _1733_/A4 _1703_/B _2160_/Q _2054_/Q _1708_/S VDD VDD VSS VSS gf180mcu_fd_sc_mcu7t5v0__nand4_1
X_1637_ _2008_/Q input17/Z _1641_/S _2008_/D VDD VDD VSS VSS gf180mcu_fd_sc_mcu7t5v0__mux2_2
XFILLER_98_240 VDD VDD VSS VSS gf180mcu_fd_sc_mcu7t5v0__fillcap_32
X_1568_ _1947_/Q _1576_/I0 _1568_/S _1947_/D VDD VDD VSS VSS gf180mcu_fd_sc_mcu7t5v0__mux2_2
Xfanout448 _2190_/RN _2036_/RN VDD VDD VSS VSS gf180mcu_fd_sc_mcu7t5v0__buf_1
X_1499_ _1499_/A1 _1911_/Q _1500_/B VDD VDD VSS VSS gf180mcu_fd_sc_mcu7t5v0__nand2_1
Xfanout459 _1927_/RN _1919_/RN VDD VDD VSS VSS gf180mcu_fd_sc_mcu7t5v0__buf_1
XFILLER_98_284 VDD VDD VSS VSS gf180mcu_fd_sc_mcu7t5v0__fill_1
XFILLER_86_457 VDD VDD VSS VSS gf180mcu_fd_sc_mcu7t5v0__fillcap_8
XFILLER_58_159 VDD VDD VSS VSS gf180mcu_fd_sc_mcu7t5v0__fill_2
XFILLER_73_129 VDD VDD VSS VSS gf180mcu_fd_sc_mcu7t5v0__fill_1
XFILLER_66_181 VDD VDD VSS VSS gf180mcu_fd_sc_mcu7t5v0__fill_1
XFILLER_54_321 VDD VDD VSS VSS gf180mcu_fd_sc_mcu7t5v0__fill_1
XFILLER_39_373 VDD VDD VSS VSS gf180mcu_fd_sc_mcu7t5v0__fillcap_16
XTAP_TAPCELL_ROW_37_563 VDD VSS gf180mcu_fd_sc_mcu7t5v0__filltie
XFILLER_54_387 VDD VDD VSS VSS gf180mcu_fd_sc_mcu7t5v0__fillcap_32
XFILLER_10_424 VDD VDD VSS VSS gf180mcu_fd_sc_mcu7t5v0__fillcap_8
XFILLER_22_273 VDD VDD VSS VSS gf180mcu_fd_sc_mcu7t5v0__fill_1
XFILLER_50_593 VDD VDD VSS VSS gf180mcu_fd_sc_mcu7t5v0__fill_2
XFILLER_2_667 VDD VDD VSS VSS gf180mcu_fd_sc_mcu7t5v0__fillcap_16
XTAP_TAPCELL_ROW_9_299 VDD VSS gf180mcu_fd_sc_mcu7t5v0__filltie
XFILLER_77_457 VDD VDD VSS VSS gf180mcu_fd_sc_mcu7t5v0__fill_2
XFILLER_77_446 VDD VDD VSS VSS gf180mcu_fd_sc_mcu7t5v0__fillcap_4
XFILLER_18_524 VDD VDD VSS VSS gf180mcu_fd_sc_mcu7t5v0__fill_1
XFILLER_92_427 VDD VDD VSS VSS gf180mcu_fd_sc_mcu7t5v0__fillcap_8
XFILLER_58_693 VDD VDD VSS VSS gf180mcu_fd_sc_mcu7t5v0__fill_1
XTAP_TAPCELL_ROW_63_809 VDD VSS gf180mcu_fd_sc_mcu7t5v0__filltie
XTAP_TAPCELL_ROW_71_886 VDD VSS gf180mcu_fd_sc_mcu7t5v0__filltie
Xclkload14 _2082_/CLK clkload14/Z VDD VDD VSS VSS gf180mcu_fd_sc_mcu7t5v0__clkbuf_2
X_1422_ _2062_/Q _1870_/Q _1423_/S _1870_/D VDD VDD VSS VSS gf180mcu_fd_sc_mcu7t5v0__mux2_2
XFILLER_48_4 VDD VDD VSS VSS gf180mcu_fd_sc_mcu7t5v0__fill_1
X_1353_ _1353_/A1 _1353_/A2 _1354_/A3 _2112_/Q _1355_/A3 VDD VDD VSS VSS gf180mcu_fd_sc_mcu7t5v0__nand4_1
X_1284_ _2171_/Q _1284_/A2 _1284_/Z VDD VDD VSS VSS gf180mcu_fd_sc_mcu7t5v0__or2_1
XTAP_TAPCELL_ROW_79_964 VDD VSS gf180mcu_fd_sc_mcu7t5v0__filltie
XFILLER_68_468 VDD VDD VSS VSS gf180mcu_fd_sc_mcu7t5v0__fillcap_32
XFILLER_68_457 VDD VDD VSS VSS gf180mcu_fd_sc_mcu7t5v0__fill_1
XFILLER_95_276 VDD VDD VSS VSS gf180mcu_fd_sc_mcu7t5v0__fillcap_4
XFILLER_36_387 VDD VDD VSS VSS gf180mcu_fd_sc_mcu7t5v0__fill_2
XTAP_TAPCELL_ROW_34_533 VDD VSS gf180mcu_fd_sc_mcu7t5v0__filltie
Xclkload8 clkload8/I clkload8/Z VDD VDD VSS VSS gf180mcu_fd_sc_mcu7t5v0__clkbuf_2
X_0999_ _2123_/D _2122_/D _1501_/A3 VDD VDD VSS VSS gf180mcu_fd_sc_mcu7t5v0__nand2_1
XTAP_TAPCELL_ROW_98_1148 VDD VSS gf180mcu_fd_sc_mcu7t5v0__filltie
Xfanout256 _1247_/A1 _1230_/A1 VDD VDD VSS VSS gf180mcu_fd_sc_mcu7t5v0__dlyb_1
Xfanout267 _1617_/ZN _1621_/S VDD VDD VSS VSS gf180mcu_fd_sc_mcu7t5v0__dlyb_1
XTAP_TAPCELL_ROW_6_269 VDD VSS gf180mcu_fd_sc_mcu7t5v0__filltie
XFILLER_86_287 VDD VDD VSS VSS gf180mcu_fd_sc_mcu7t5v0__fill_2
XFILLER_46_107 VDD VDD VSS VSS gf180mcu_fd_sc_mcu7t5v0__fill_2
XFILLER_82_471 VDD VDD VSS VSS gf180mcu_fd_sc_mcu7t5v0__fillcap_8
XFILLER_24_31 VDD VDD VSS VSS gf180mcu_fd_sc_mcu7t5v0__fillcap_4
XFILLER_2_453 VDD VDD VSS VSS gf180mcu_fd_sc_mcu7t5v0__fill_2
XFILLER_77_265 VDD VDD VSS VSS gf180mcu_fd_sc_mcu7t5v0__fillcap_4
XTAP_TAPCELL_ROW_76_934 VDD VSS gf180mcu_fd_sc_mcu7t5v0__filltie
XFILLER_65_416 VDD VDD VSS VSS gf180mcu_fd_sc_mcu7t5v0__fillcap_4
XTAP_TAPCELL_ROW_86_1030 VDD VSS gf180mcu_fd_sc_mcu7t5v0__filltie
XTAP_TAPCELL_ROW_48_669 VDD VSS gf180mcu_fd_sc_mcu7t5v0__filltie
XFILLER_18_387 VDD VDD VSS VSS gf180mcu_fd_sc_mcu7t5v0__fillcap_64
XFILLER_21_519 VDD VDD VSS VSS gf180mcu_fd_sc_mcu7t5v0__fill_2
XFILLER_61_688 VDD VDD VSS VSS gf180mcu_fd_sc_mcu7t5v0__fillcap_4
XFILLER_60_132 VDD VDD VSS VSS gf180mcu_fd_sc_mcu7t5v0__fill_1
XFILLER_14_593 VDD VDD VSS VSS gf180mcu_fd_sc_mcu7t5v0__fill_2
X_1971_ _1971_/D _2130_/RN _1971_/CLK _1971_/Q VDD VDD VSS VSS gf180mcu_fd_sc_mcu7t5v0__dffrnq_1
XTAP_TAPCELL_ROW_31_503 VDD VSS gf180mcu_fd_sc_mcu7t5v0__filltie
XFILLER_60_198 VDD VDD VSS VSS gf180mcu_fd_sc_mcu7t5v0__fill_1
X_0922_ _2091_/Q _1151_/A1 VDD VDD VSS VSS gf180mcu_fd_sc_mcu7t5v0__clkinv_1
XFILLER_53_2 VDD VDD VSS VSS gf180mcu_fd_sc_mcu7t5v0__fillcap_8
X_1405_ _1405_/I _1405_/ZN VDD VDD VSS VSS gf180mcu_fd_sc_mcu7t5v0__clkinv_1
X_1336_ input85/Z _1336_/A2 _1373_/A3 _1340_/A2 VDD VDD VSS VSS gf180mcu_fd_sc_mcu7t5v0__nand3_1
Xinput1 cfg_addr_i[0] input1/Z VDD VDD VSS VSS gf180mcu_fd_sc_mcu7t5v0__dlyb_1
XTAP_TAPCELL_ROW_3_239 VDD VSS gf180mcu_fd_sc_mcu7t5v0__filltie
XFILLER_56_438 VDD VDD VSS VSS gf180mcu_fd_sc_mcu7t5v0__fill_1
X_1267_ _1270_/A2 _1267_/A2 _1268_/A3 VDD VDD VSS VSS gf180mcu_fd_sc_mcu7t5v0__nand2_1
X_1198_ _2130_/Q _2131_/Q _1200_/A2 VDD VDD VSS VSS gf180mcu_fd_sc_mcu7t5v0__nor2_1
XFILLER_83_279 VDD VDD VSS VSS gf180mcu_fd_sc_mcu7t5v0__fill_1
XFILLER_71_419 VDD VDD VSS VSS gf180mcu_fd_sc_mcu7t5v0__fill_1
XFILLER_36_173 VDD VDD VSS VSS gf180mcu_fd_sc_mcu7t5v0__fill_2
XTAP_TAPCELL_ROW_19_393 VDD VSS gf180mcu_fd_sc_mcu7t5v0__filltie
XFILLER_52_655 VDD VDD VSS VSS gf180mcu_fd_sc_mcu7t5v0__fillcap_8
XPHY_EDGE_ROW_5_Left_104 VDD VSS gf180mcu_fd_sc_mcu7t5v0__endcap
XFILLER_86_37 VDD VDD VSS VSS gf180mcu_fd_sc_mcu7t5v0__fillcap_64
XFILLER_59_298 VDD VDD VSS VSS gf180mcu_fd_sc_mcu7t5v0__fill_1
XFILLER_47_438 VDD VDD VSS VSS gf180mcu_fd_sc_mcu7t5v0__fillcap_8
XTAP_TAPCELL_ROW_73_904 VDD VSS gf180mcu_fd_sc_mcu7t5v0__filltie
XFILLER_74_279 VDD VDD VSS VSS gf180mcu_fd_sc_mcu7t5v0__fillcap_32
XTAP_TAPCELL_ROW_45_639 VDD VSS gf180mcu_fd_sc_mcu7t5v0__filltie
XFILLER_15_357 VDD VDD VSS VSS gf180mcu_fd_sc_mcu7t5v0__fill_1
XTAP_TAPCELL_ROW_81_981 VDD VSS gf180mcu_fd_sc_mcu7t5v0__filltie
XFILLER_11_574 VDD VDD VSS VSS gf180mcu_fd_sc_mcu7t5v0__fill_1
Xwire410 wire410/I cfg_rx_size_o[11] VDD VDD VSS VSS gf180mcu_fd_sc_mcu7t5v0__clkbuf_3
XFILLER_7_534 VDD VDD VSS VSS gf180mcu_fd_sc_mcu7t5v0__fill_1
Xload_slew437 _1999_/RN _2031_/RN VDD VDD VSS VSS gf180mcu_fd_sc_mcu7t5v0__clkbuf_3
X_2170_ _2170_/D _2172_/RN _2170_/CLK _2170_/Q VDD VDD VSS VSS gf180mcu_fd_sc_mcu7t5v0__dffrnq_1
X_1121_ _1119_/Z _1157_/B2 _1121_/Z VDD VDD VSS VSS gf180mcu_fd_sc_mcu7t5v0__or2_1
XTAP_TAPCELL_ROW_0_209 VDD VSS gf180mcu_fd_sc_mcu7t5v0__filltie
XPHY_EDGE_ROW_69_Left_168 VDD VSS gf180mcu_fd_sc_mcu7t5v0__endcap
XFILLER_93_533 VDD VDD VSS VSS gf180mcu_fd_sc_mcu7t5v0__fillcap_16
X_1052_ _2152_/D _2153_/D _1057_/B1 VDD VDD VSS VSS gf180mcu_fd_sc_mcu7t5v0__nand2_1
XFILLER_65_279 VDD VDD VSS VSS gf180mcu_fd_sc_mcu7t5v0__fill_1
XFILLER_53_419 VDD VDD VSS VSS gf180mcu_fd_sc_mcu7t5v0__fill_1
XFILLER_46_493 VDD VDD VSS VSS gf180mcu_fd_sc_mcu7t5v0__fill_1
XTAP_TAPCELL_ROW_16_363 VDD VSS gf180mcu_fd_sc_mcu7t5v0__filltie
XFILLER_21_349 VDD VDD VSS VSS gf180mcu_fd_sc_mcu7t5v0__fill_1
X_1954_ _1954_/D _1954_/RN _1954_/CLK _1954_/Q VDD VDD VSS VSS gf180mcu_fd_sc_mcu7t5v0__dffrnq_1
X_0905_ _1319_/C _0982_/A1 VDD VDD VSS VSS gf180mcu_fd_sc_mcu7t5v0__clkinv_1
X_1885_ _1885_/D _2156_/RN _2154_/CLK _1885_/Q VDD VDD VSS VSS gf180mcu_fd_sc_mcu7t5v0__dffrnq_1
XTAP_TAPCELL_ROW_95_1118 VDD VSS gf180mcu_fd_sc_mcu7t5v0__filltie
XPHY_EDGE_ROW_78_Left_177 VDD VSS gf180mcu_fd_sc_mcu7t5v0__endcap
XPHY_EDGE_ROW_87_Left_186 VDD VSS gf180mcu_fd_sc_mcu7t5v0__endcap
XFILLER_84_500 VDD VDD VSS VSS gf180mcu_fd_sc_mcu7t5v0__fillcap_16
XFILLER_56_29 VDD VDD VSS VSS gf180mcu_fd_sc_mcu7t5v0__fillcap_4
XFILLER_56_18 VDD VDD VSS VSS gf180mcu_fd_sc_mcu7t5v0__fill_2
XFILLER_29_438 VDD VDD VSS VSS gf180mcu_fd_sc_mcu7t5v0__fill_2
X_1319_ _0906_/I _0907_/I _1319_/B _1319_/C _1376_/A1 VDD VDD VSS VSS gf180mcu_fd_sc_mcu7t5v0__oai211_1
XFILLER_84_599 VDD VDD VSS VSS gf180mcu_fd_sc_mcu7t5v0__fill_1
XFILLER_25_611 VDD VDD VSS VSS gf180mcu_fd_sc_mcu7t5v0__fillcap_8
XTAP_TAPCELL_ROW_42_609 VDD VSS gf180mcu_fd_sc_mcu7t5v0__filltie
XPHY_EDGE_ROW_96_Left_195 VDD VSS gf180mcu_fd_sc_mcu7t5v0__endcap
XFILLER_20_382 VDD VDD VSS VSS gf180mcu_fd_sc_mcu7t5v0__fill_2
XTAP_TAPCELL_ROW_50_686 VDD VSS gf180mcu_fd_sc_mcu7t5v0__filltie
XFILLER_79_349 VDD VDD VSS VSS gf180mcu_fd_sc_mcu7t5v0__fill_1
Xoutput190 _2024_/Q wire370/I VDD VDD VSS VSS gf180mcu_fd_sc_mcu7t5v0__buf_1
XFILLER_47_202 VDD VDD VSS VSS gf180mcu_fd_sc_mcu7t5v0__fillcap_8
XFILLER_47_235 VDD VDD VSS VSS gf180mcu_fd_sc_mcu7t5v0__fill_1
XFILLER_35_419 VDD VDD VSS VSS gf180mcu_fd_sc_mcu7t5v0__fill_1
XTAP_TAPCELL_ROW_58_764 VDD VSS gf180mcu_fd_sc_mcu7t5v0__filltie
XTAP_TAPCELL_ROW_83_1000 VDD VSS gf180mcu_fd_sc_mcu7t5v0__filltie
XFILLER_90_558 VDD VDD VSS VSS gf180mcu_fd_sc_mcu7t5v0__fill_2
XFILLER_15_154 VDD VDD VSS VSS gf180mcu_fd_sc_mcu7t5v0__fill_1
XFILLER_43_485 VDD VDD VSS VSS gf180mcu_fd_sc_mcu7t5v0__fillcap_4
XTAP_TAPCELL_ROW_13_333 VDD VSS gf180mcu_fd_sc_mcu7t5v0__filltie
Xwire240 wire240/I cfg_data_o[7] VDD VDD VSS VSS gf180mcu_fd_sc_mcu7t5v0__clkbuf_3
X_1670_ _1670_/A1 _2039_/Q _1671_/A2 VDD VDD VSS VSS gf180mcu_fd_sc_mcu7t5v0__nand2_1
Xwire284 wire284/I rx_char_event_o VDD VDD VSS VSS gf180mcu_fd_sc_mcu7t5v0__clkbuf_3
Xwire295 wire295/I cfg_data_o[30] VDD VDD VSS VSS gf180mcu_fd_sc_mcu7t5v0__clkbuf_3
Xload_slew234 _1426_/S _1432_/S VDD VDD VSS VSS gf180mcu_fd_sc_mcu7t5v0__buf_2
X_2153_ _2153_/D _1895_/RN _2153_/CLK _2153_/Q VDD VDD VSS VSS gf180mcu_fd_sc_mcu7t5v0__dffsnq_1
X_1104_ _2087_/Q _2163_/Q _1104_/Z VDD VDD VSS VSS gf180mcu_fd_sc_mcu7t5v0__or2_1
XFILLER_93_352 VDD VDD VSS VSS gf180mcu_fd_sc_mcu7t5v0__fillcap_4
XFILLER_66_588 VDD VDD VSS VSS gf180mcu_fd_sc_mcu7t5v0__fillcap_4
X_2084_ _2084_/D _2108_/RN _2187_/CLK _2084_/Q VDD VDD VSS VSS gf180mcu_fd_sc_mcu7t5v0__dffrnq_1
X_1035_ _1021_/Z _1022_/Z _1023_/Z _1028_/Z _1039_/A2 VDD VDD VSS VSS gf180mcu_fd_sc_mcu7t5v0__nor4_1
XFILLER_61_282 VDD VDD VSS VSS gf180mcu_fd_sc_mcu7t5v0__fillcap_16
X_1937_ _1937_/D _1957_/RN _2000_/CLK _1937_/Q VDD VDD VSS VSS gf180mcu_fd_sc_mcu7t5v0__dffrnq_1
X_1868_ _1868_/D _1887_/RN _2063_/CLK _1868_/Q VDD VDD VSS VSS gf180mcu_fd_sc_mcu7t5v0__dffrnq_1
Xinput81 cfg_tx_bytes_left_i[6] input81/Z VDD VDD VSS VSS gf180mcu_fd_sc_mcu7t5v0__dlyb_1
Xinput70 cfg_tx_bytes_left_i[10] input70/Z VDD VDD VSS VSS gf180mcu_fd_sc_mcu7t5v0__dlyb_1
X_1799_ _1815_/A1 _1908_/Q _1900_/Q _1815_/B2 _1799_/C _1801_/A1 VDD VDD VSS VSS gf180mcu_fd_sc_mcu7t5v0__aoi221_1
Xmax_cap551 _2133_/RN _2136_/RN VDD VDD VSS VSS gf180mcu_fd_sc_mcu7t5v0__buf_2
Xmax_cap540 _1563_/S _1561_/S VDD VDD VSS VSS gf180mcu_fd_sc_mcu7t5v0__clkbuf_1
Xinput92 cfg_tx_curr_addr_i[5] input92/Z VDD VDD VSS VSS gf180mcu_fd_sc_mcu7t5v0__dlyb_1
XFILLER_17_419 VDD VDD VSS VSS gf180mcu_fd_sc_mcu7t5v0__fill_1
XTAP_TAPCELL_ROW_55_734 VDD VSS gf180mcu_fd_sc_mcu7t5v0__filltie
XFILLER_25_430 VDD VDD VSS VSS gf180mcu_fd_sc_mcu7t5v0__fill_2
XFILLER_13_625 VDD VDD VSS VSS gf180mcu_fd_sc_mcu7t5v0__fillcap_4
XFILLER_25_474 VDD VDD VSS VSS gf180mcu_fd_sc_mcu7t5v0__fillcap_4
XTAP_TAPCELL_ROW_27_469 VDD VSS gf180mcu_fd_sc_mcu7t5v0__filltie
XFILLER_80_580 VDD VDD VSS VSS gf180mcu_fd_sc_mcu7t5v0__fill_2
XFILLER_40_444 VDD VDD VSS VSS gf180mcu_fd_sc_mcu7t5v0__fillcap_4
XFILLER_32_31 VDD VDD VSS VSS gf180mcu_fd_sc_mcu7t5v0__fillcap_4
XTAP_TAPCELL_ROW_10_303 VDD VSS gf180mcu_fd_sc_mcu7t5v0__filltie
XFILLER_79_157 VDD VDD VSS VSS gf180mcu_fd_sc_mcu7t5v0__fillcap_32
XFILLER_57_50 VDD VDD VSS VSS gf180mcu_fd_sc_mcu7t5v0__fillcap_16
XFILLER_48_544 VDD VDD VSS VSS gf180mcu_fd_sc_mcu7t5v0__fillcap_32
XFILLER_63_503 VDD VDD VSS VSS gf180mcu_fd_sc_mcu7t5v0__fillcap_8
XFILLER_57_72 VDD VDD VSS VSS gf180mcu_fd_sc_mcu7t5v0__fillcap_64
XFILLER_35_205 VDD VDD VSS VSS gf180mcu_fd_sc_mcu7t5v0__fillcap_4
XFILLER_90_300 VDD VDD VSS VSS gf180mcu_fd_sc_mcu7t5v0__fillcap_8
XFILLER_63_536 VDD VDD VSS VSS gf180mcu_fd_sc_mcu7t5v0__fillcap_16
XFILLER_43_282 VDD VDD VSS VSS gf180mcu_fd_sc_mcu7t5v0__fillcap_16
XFILLER_43_271 VDD VDD VSS VSS gf180mcu_fd_sc_mcu7t5v0__fillcap_8
XFILLER_12_691 VDD VDD VSS VSS gf180mcu_fd_sc_mcu7t5v0__fill_2
X_1722_ _1718_/S _1722_/A2 _1722_/A3 _1722_/B _2062_/D VDD VDD VSS VSS gf180mcu_fd_sc_mcu7t5v0__oai31_1
X_1653_ _2023_/Q input32/Z _1653_/S _2023_/D VDD VDD VSS VSS gf180mcu_fd_sc_mcu7t5v0__mux2_2
XPHY_EDGE_ROW_9_Right_9 VDD VSS gf180mcu_fd_sc_mcu7t5v0__endcap
X_1584_ _1958_/Q input31/Z _1672_/S _1958_/D VDD VDD VSS VSS gf180mcu_fd_sc_mcu7t5v0__mux2_2
XFILLER_58_319 VDD VDD VSS VSS gf180mcu_fd_sc_mcu7t5v0__fill_1
XFILLER_94_661 VDD VDD VSS VSS gf180mcu_fd_sc_mcu7t5v0__fillcap_4
X_2136_ _2136_/D _2136_/RN _2138_/CLK _2136_/Q VDD VDD VSS VSS gf180mcu_fd_sc_mcu7t5v0__dffrnq_1
XFILLER_94_683 VDD VDD VSS VSS gf180mcu_fd_sc_mcu7t5v0__fillcap_8
XFILLER_19_290 VDD VDD VSS VSS gf180mcu_fd_sc_mcu7t5v0__fill_2
XFILLER_26_249 VDD VDD VSS VSS gf180mcu_fd_sc_mcu7t5v0__fill_1
X_2067_ _2067_/D _2067_/RN clkload9/I _2067_/Q VDD VDD VSS VSS gf180mcu_fd_sc_mcu7t5v0__dffrnq_1
X_1018_ _1501_/A3 _1821_/C _1018_/B _1018_/C _2126_/D VDD VDD VSS VSS gf180mcu_fd_sc_mcu7t5v0__oai211_1
XTAP_TAPCELL_ROW_52_704 VDD VSS gf180mcu_fd_sc_mcu7t5v0__filltie
XFILLER_34_271 VDD VDD VSS VSS gf180mcu_fd_sc_mcu7t5v0__fillcap_4
XTAP_TAPCELL_ROW_24_439 VDD VSS gf180mcu_fd_sc_mcu7t5v0__filltie
XTAP_TAPCELL_ROW_60_781 VDD VSS gf180mcu_fd_sc_mcu7t5v0__filltie
XFILLER_89_422 VDD VDD VSS VSS gf180mcu_fd_sc_mcu7t5v0__fillcap_16
XFILLER_78_49 VDD VDD VSS VSS gf180mcu_fd_sc_mcu7t5v0__fill_2
XFILLER_89_477 VDD VDD VSS VSS gf180mcu_fd_sc_mcu7t5v0__fillcap_8
XFILLER_94_37 VDD VDD VSS VSS gf180mcu_fd_sc_mcu7t5v0__fillcap_64
XFILLER_57_352 VDD VDD VSS VSS gf180mcu_fd_sc_mcu7t5v0__fillcap_16
XFILLER_84_171 VDD VDD VSS VSS gf180mcu_fd_sc_mcu7t5v0__fillcap_4
XFILLER_13_422 VDD VDD VSS VSS gf180mcu_fd_sc_mcu7t5v0__fill_2
XFILLER_25_282 VDD VDD VSS VSS gf180mcu_fd_sc_mcu7t5v0__fillcap_16
XFILLER_43_63 VDD VDD VSS VSS gf180mcu_fd_sc_mcu7t5v0__fillcap_4
XFILLER_13_488 VDD VDD VSS VSS gf180mcu_fd_sc_mcu7t5v0__fill_2
XFILLER_40_263 VDD VDD VSS VSS gf180mcu_fd_sc_mcu7t5v0__fillcap_8
XFILLER_5_632 VDD VDD VSS VSS gf180mcu_fd_sc_mcu7t5v0__fillcap_32
XTAP_TAPCELL_ROW_89_1061 VDD VSS gf180mcu_fd_sc_mcu7t5v0__filltie
XFILLER_76_683 VDD VDD VSS VSS gf180mcu_fd_sc_mcu7t5v0__fillcap_8
XFILLER_63_322 VDD VDD VSS VSS gf180mcu_fd_sc_mcu7t5v0__fillcap_4
XFILLER_91_664 VDD VDD VSS VSS gf180mcu_fd_sc_mcu7t5v0__fillcap_16
XTAP_TAPCELL_ROW_21_409 VDD VSS gf180mcu_fd_sc_mcu7t5v0__filltie
XFILLER_83_2 VDD VDD VSS VSS gf180mcu_fd_sc_mcu7t5v0__fillcap_64
X_1705_ _1705_/A1 _1705_/A2 _1705_/B _2055_/D VDD VDD VSS VSS gf180mcu_fd_sc_mcu7t5v0__aoi21_1
X_1636_ _2007_/Q input6/Z _1647_/S _2007_/D VDD VDD VSS VSS gf180mcu_fd_sc_mcu7t5v0__mux2_2
X_1567_ _1946_/Q _1575_/I0 _1568_/S _1946_/D VDD VDD VSS VSS gf180mcu_fd_sc_mcu7t5v0__mux2_2
Xfanout416 _2129_/Q _1832_/A2 VDD VDD VSS VSS gf180mcu_fd_sc_mcu7t5v0__dlyb_1
Xfanout427 input5/Z _1328_/B VDD VDD VSS VSS gf180mcu_fd_sc_mcu7t5v0__dlya_1
Xfanout438 fanout458/Z _2033_/RN VDD VDD VSS VSS gf180mcu_fd_sc_mcu7t5v0__dlyb_1
XFILLER_98_274 VDD VDD VSS VSS gf180mcu_fd_sc_mcu7t5v0__fillcap_8
XFILLER_86_403 VDD VDD VSS VSS gf180mcu_fd_sc_mcu7t5v0__fill_1
X_1498_ _1577_/A1 _1472_/Z _1511_/C _1527_/A2 VDD VDD VSS VSS gf180mcu_fd_sc_mcu7t5v0__nand3_1
Xfanout449 _2190_/RN _2108_/RN VDD VDD VSS VSS gf180mcu_fd_sc_mcu7t5v0__dlyb_1
XFILLER_39_352 VDD VDD VSS VSS gf180mcu_fd_sc_mcu7t5v0__fillcap_4
X_2119_ _2119_/D _2123_/RN clkload8/I _2119_/Q VDD VDD VSS VSS gf180mcu_fd_sc_mcu7t5v0__dffrnq_1
XFILLER_82_664 VDD VDD VSS VSS gf180mcu_fd_sc_mcu7t5v0__fill_1
XTAP_TAPCELL_ROW_37_564 VDD VSS gf180mcu_fd_sc_mcu7t5v0__filltie
XFILLER_22_263 VDD VDD VSS VSS gf180mcu_fd_sc_mcu7t5v0__fillcap_8
XFILLER_10_469 VDD VDD VSS VSS gf180mcu_fd_sc_mcu7t5v0__fill_2
XFILLER_58_683 VDD VDD VSS VSS gf180mcu_fd_sc_mcu7t5v0__fillcap_8
XFILLER_73_664 VDD VDD VSS VSS gf180mcu_fd_sc_mcu7t5v0__fillcap_16
XFILLER_72_174 VDD VDD VSS VSS gf180mcu_fd_sc_mcu7t5v0__fill_1
XFILLER_13_263 VDD VDD VSS VSS gf180mcu_fd_sc_mcu7t5v0__fill_1
XTAP_TAPCELL_ROW_71_887 VDD VSS gf180mcu_fd_sc_mcu7t5v0__filltie
Xclkload15 _2142_/CLK clkload15/Z VDD VDD VSS VSS gf180mcu_fd_sc_mcu7t5v0__clkbuf_2
XFILLER_5_473 VDD VDD VSS VSS gf180mcu_fd_sc_mcu7t5v0__fillcap_16
X_1421_ _2061_/Q _1869_/Q _1421_/S _1869_/D VDD VDD VSS VSS gf180mcu_fd_sc_mcu7t5v0__mux2_2
X_1352_ _1976_/Q _1179_/Z _1333_/Z input46/Z _1355_/A2 VDD VDD VSS VSS gf180mcu_fd_sc_mcu7t5v0__aoi22_1
X_1283_ _1283_/A1 _1287_/A2 _2170_/D VDD VDD VSS VSS gf180mcu_fd_sc_mcu7t5v0__nor2_1
XTAP_TAPCELL_ROW_79_965 VDD VSS gf180mcu_fd_sc_mcu7t5v0__filltie
XPHY_EDGE_ROW_50_Left_149 VDD VSS gf180mcu_fd_sc_mcu7t5v0__endcap
XFILLER_95_288 VDD VDD VSS VSS gf180mcu_fd_sc_mcu7t5v0__fill_1
XFILLER_48_193 VDD VDD VSS VSS gf180mcu_fd_sc_mcu7t5v0__fill_1
XTAP_TAPCELL_ROW_34_534 VDD VSS gf180mcu_fd_sc_mcu7t5v0__filltie
XFILLER_63_174 VDD VDD VSS VSS gf180mcu_fd_sc_mcu7t5v0__fillcap_16
XFILLER_51_325 VDD VDD VSS VSS gf180mcu_fd_sc_mcu7t5v0__fillcap_16
XFILLER_32_594 VDD VDD VSS VSS gf180mcu_fd_sc_mcu7t5v0__fill_1
Xclkload9 clkload9/I clkload9/Z VDD VDD VSS VSS gf180mcu_fd_sc_mcu7t5v0__clkbuf_2
X_0998_ _1933_/Q _1934_/Q _1535_/A1 VDD VDD VSS VSS gf180mcu_fd_sc_mcu7t5v0__nand2_1
XTAP_TAPCELL_ROW_98_1149 VDD VSS gf180mcu_fd_sc_mcu7t5v0__filltie
X_1619_ _1991_/Q input17/Z _1621_/S _1991_/D VDD VDD VSS VSS gf180mcu_fd_sc_mcu7t5v0__mux2_2
Xfanout235 _1304_/A4 _1294_/A4 VDD VDD VSS VSS gf180mcu_fd_sc_mcu7t5v0__dlyb_1
Xfanout257 _1196_/ZN _1247_/A1 VDD VDD VSS VSS gf180mcu_fd_sc_mcu7t5v0__dlyb_1
XFILLER_27_344 VDD VDD VSS VSS gf180mcu_fd_sc_mcu7t5v0__fillcap_4
XFILLER_82_461 VDD VDD VSS VSS gf180mcu_fd_sc_mcu7t5v0__fill_2
XFILLER_55_664 VDD VDD VSS VSS gf180mcu_fd_sc_mcu7t5v0__fillcap_16
XFILLER_54_174 VDD VDD VSS VSS gf180mcu_fd_sc_mcu7t5v0__fill_1
XFILLER_42_314 VDD VDD VSS VSS gf180mcu_fd_sc_mcu7t5v0__fill_1
XFILLER_30_509 VDD VDD VSS VSS gf180mcu_fd_sc_mcu7t5v0__fill_1
XFILLER_70_667 VDD VDD VSS VSS gf180mcu_fd_sc_mcu7t5v0__fillcap_16
XFILLER_10_222 VDD VDD VSS VSS gf180mcu_fd_sc_mcu7t5v0__fillcap_4
XFILLER_40_53 VDD VDD VSS VSS gf180mcu_fd_sc_mcu7t5v0__fill_2
XFILLER_2_421 VDD VDD VSS VSS gf180mcu_fd_sc_mcu7t5v0__fill_1
XFILLER_77_200 VDD VDD VSS VSS gf180mcu_fd_sc_mcu7t5v0__fill_2
XFILLER_49_51 VDD VDD VSS VSS gf180mcu_fd_sc_mcu7t5v0__fill_2
XTAP_TAPCELL_ROW_76_935 VDD VSS gf180mcu_fd_sc_mcu7t5v0__filltie
XFILLER_92_247 VDD VDD VSS VSS gf180mcu_fd_sc_mcu7t5v0__fillcap_64
XTAP_TAPCELL_ROW_86_1031 VDD VSS gf180mcu_fd_sc_mcu7t5v0__filltie
X_1970_ _1970_/D _2092_/RN _1975_/CLK _1970_/Q VDD VDD VSS VSS gf180mcu_fd_sc_mcu7t5v0__dffrnq_1
X_0921_ _2090_/Q _1145_/A1 VDD VDD VSS VSS gf180mcu_fd_sc_mcu7t5v0__clkinv_1
XTAP_TAPCELL_ROW_31_504 VDD VSS gf180mcu_fd_sc_mcu7t5v0__filltie
XFILLER_60_177 VDD VDD VSS VSS gf180mcu_fd_sc_mcu7t5v0__fillcap_4
XFILLER_60_4 VDD VDD VSS VSS gf180mcu_fd_sc_mcu7t5v0__fill_1
X_1404_ input75/Z _1404_/A2 _1404_/B1 input45/Z _1405_/I VDD VDD VSS VSS gf180mcu_fd_sc_mcu7t5v0__aoi22_1
XFILLER_96_520 VDD VDD VSS VSS gf180mcu_fd_sc_mcu7t5v0__fillcap_4
X_1335_ _1335_/A1 _1328_/B _1673_/A2 input1/Z _1395_/B1 VDD VDD VSS VSS gf180mcu_fd_sc_mcu7t5v0__nor4_1
XFILLER_68_244 VDD VDD VSS VSS gf180mcu_fd_sc_mcu7t5v0__fill_1
Xinput2 cfg_addr_i[1] input2/Z VDD VDD VSS VSS gf180mcu_fd_sc_mcu7t5v0__dlyb_1
XFILLER_96_597 VDD VDD VSS VSS gf180mcu_fd_sc_mcu7t5v0__fillcap_64
X_1266_ _2165_/Q _2166_/Q _1260_/Z _1274_/A3 VDD VDD VSS VSS gf180mcu_fd_sc_mcu7t5v0__nand3_1
X_1197_ _1230_/A1 _2130_/Q _2130_/D VDD VDD VSS VSS gf180mcu_fd_sc_mcu7t5v0__nor2_1
XFILLER_24_325 VDD VDD VSS VSS gf180mcu_fd_sc_mcu7t5v0__fill_2
XFILLER_36_185 VDD VDD VSS VSS gf180mcu_fd_sc_mcu7t5v0__fillcap_4
XTAP_TAPCELL_ROW_19_394 VDD VSS gf180mcu_fd_sc_mcu7t5v0__filltie
XFILLER_52_667 VDD VDD VSS VSS gf180mcu_fd_sc_mcu7t5v0__fillcap_8
XFILLER_20_597 VDD VDD VSS VSS gf180mcu_fd_sc_mcu7t5v0__fillcap_4
XFILLER_10_34 VDD VDD VSS VSS gf180mcu_fd_sc_mcu7t5v0__fill_1
XFILLER_74_247 VDD VDD VSS VSS gf180mcu_fd_sc_mcu7t5v0__fillcap_16
XFILLER_74_225 VDD VDD VSS VSS gf180mcu_fd_sc_mcu7t5v0__fillcap_8
XFILLER_28_664 VDD VDD VSS VSS gf180mcu_fd_sc_mcu7t5v0__fill_1
XTAP_TAPCELL_ROW_73_905 VDD VSS gf180mcu_fd_sc_mcu7t5v0__filltie
XFILLER_55_461 VDD VDD VSS VSS gf180mcu_fd_sc_mcu7t5v0__fillcap_16
XFILLER_30_317 VDD VDD VSS VSS gf180mcu_fd_sc_mcu7t5v0__fillcap_16
XTAP_TAPCELL_ROW_81_982 VDD VSS gf180mcu_fd_sc_mcu7t5v0__filltie
XFILLER_42_177 VDD VDD VSS VSS gf180mcu_fd_sc_mcu7t5v0__fillcap_16
Xwire400 wire400/I cfg_rx_size_o[6] VDD VDD VSS VSS gf180mcu_fd_sc_mcu7t5v0__clkbuf_3
Xwire411 wire411/I cfg_rx_size_o[10] VDD VDD VSS VSS gf180mcu_fd_sc_mcu7t5v0__clkbuf_3
XFILLER_7_524 VDD VDD VSS VSS gf180mcu_fd_sc_mcu7t5v0__fillcap_8
XFILLER_78_520 VDD VDD VSS VSS gf180mcu_fd_sc_mcu7t5v0__fillcap_4
XTAP_TAPCELL_ROW_92_1090 VDD VSS gf180mcu_fd_sc_mcu7t5v0__filltie
X_1120_ _2092_/Q _2167_/Q _1157_/B2 VDD VDD VSS VSS gf180mcu_fd_sc_mcu7t5v0__nor2_1
XFILLER_78_597 VDD VDD VSS VSS gf180mcu_fd_sc_mcu7t5v0__fillcap_4
XFILLER_76_93 VDD VDD VSS VSS gf180mcu_fd_sc_mcu7t5v0__fillcap_8
X_1051_ _1892_/Q _1893_/Q _1894_/Q _1895_/Q _1306_/S0 VDD VDD VSS VSS gf180mcu_fd_sc_mcu7t5v0__aoi22_2
XFILLER_34_645 VDD VDD VSS VSS gf180mcu_fd_sc_mcu7t5v0__fillcap_4
XTAP_TAPCELL_ROW_16_364 VDD VSS gf180mcu_fd_sc_mcu7t5v0__filltie
X_1953_ _1953_/D _1954_/RN _1954_/CLK _1953_/Q VDD VDD VSS VSS gf180mcu_fd_sc_mcu7t5v0__dffrnq_1
X_1884_ _1884_/D _1886_/RN _2063_/CLK _1884_/Q VDD VDD VSS VSS gf180mcu_fd_sc_mcu7t5v0__dffrnq_1
X_0904_ _0904_/I _0966_/A1 VDD VDD VSS VSS gf180mcu_fd_sc_mcu7t5v0__clkinv_1
XTAP_TAPCELL_ROW_95_1119 VDD VSS gf180mcu_fd_sc_mcu7t5v0__filltie
XFILLER_6_590 VDD VDD VSS VSS gf180mcu_fd_sc_mcu7t5v0__fillcap_4
XFILLER_88_317 VDD VDD VSS VSS gf180mcu_fd_sc_mcu7t5v0__fillcap_16
XFILLER_69_542 VDD VDD VSS VSS gf180mcu_fd_sc_mcu7t5v0__fill_1
XFILLER_29_406 VDD VDD VSS VSS gf180mcu_fd_sc_mcu7t5v0__fillcap_8
XFILLER_29_428 VDD VDD VSS VSS gf180mcu_fd_sc_mcu7t5v0__fill_1
X_1318_ _1604_/A2 _1604_/A4 _1604_/A3 _1320_/A1 VDD VDD VSS VSS gf180mcu_fd_sc_mcu7t5v0__nand3_1
XFILLER_56_247 VDD VDD VSS VSS gf180mcu_fd_sc_mcu7t5v0__fillcap_16
X_1249_ _1835_/B1 _2157_/Q _2158_/D VDD VDD VSS VSS gf180mcu_fd_sc_mcu7t5v0__or2_1
XFILLER_84_589 VDD VDD VSS VSS gf180mcu_fd_sc_mcu7t5v0__fillcap_4
XFILLER_56_269 VDD VDD VSS VSS gf180mcu_fd_sc_mcu7t5v0__fill_1
XFILLER_24_100 VDD VDD VSS VSS gf180mcu_fd_sc_mcu7t5v0__fillcap_4
XFILLER_37_494 VDD VDD VSS VSS gf180mcu_fd_sc_mcu7t5v0__fill_1
XFILLER_12_317 VDD VDD VSS VSS gf180mcu_fd_sc_mcu7t5v0__fillcap_16
XFILLER_24_177 VDD VDD VSS VSS gf180mcu_fd_sc_mcu7t5v0__fillcap_64
XTAP_TAPCELL_ROW_50_687 VDD VSS gf180mcu_fd_sc_mcu7t5v0__filltie
XFILLER_21_88 VDD VDD VSS VSS gf180mcu_fd_sc_mcu7t5v0__fill_2
XFILLER_4_549 VDD VDD VSS VSS gf180mcu_fd_sc_mcu7t5v0__fill_1
XFILLER_4_527 VDD VDD VSS VSS gf180mcu_fd_sc_mcu7t5v0__fillcap_16
Xoutput191 _2025_/Q wire369/I VDD VDD VSS VSS gf180mcu_fd_sc_mcu7t5v0__buf_1
Xoutput180 _2029_/Q wire380/I VDD VDD VSS VSS gf180mcu_fd_sc_mcu7t5v0__buf_1
XFILLER_94_309 VDD VDD VSS VSS gf180mcu_fd_sc_mcu7t5v0__fillcap_4
XFILLER_75_534 VDD VDD VSS VSS gf180mcu_fd_sc_mcu7t5v0__fill_2
XTAP_TAPCELL_ROW_58_765 VDD VSS gf180mcu_fd_sc_mcu7t5v0__filltie
XFILLER_75_578 VDD VDD VSS VSS gf180mcu_fd_sc_mcu7t5v0__fillcap_32
XFILLER_15_100 VDD VDD VSS VSS gf180mcu_fd_sc_mcu7t5v0__fill_1
XTAP_TAPCELL_ROW_83_1001 VDD VSS gf180mcu_fd_sc_mcu7t5v0__filltie
XFILLER_46_85 VDD VDD VSS VSS gf180mcu_fd_sc_mcu7t5v0__fillcap_4
XFILLER_16_667 VDD VDD VSS VSS gf180mcu_fd_sc_mcu7t5v0__fillcap_4
XTAP_TAPCELL_ROW_13_334 VDD VSS gf180mcu_fd_sc_mcu7t5v0__filltie
XFILLER_62_84 VDD VDD VSS VSS gf180mcu_fd_sc_mcu7t5v0__fillcap_16
Xwire241 wire241/I cfg_data_o[6] VDD VDD VSS VSS gf180mcu_fd_sc_mcu7t5v0__clkbuf_3
Xwire285 wire285/I data_tx_ready_o VDD VDD VSS VSS gf180mcu_fd_sc_mcu7t5v0__clkbuf_3
Xwire296 wire296/I cfg_data_o[29] VDD VDD VSS VSS gf180mcu_fd_sc_mcu7t5v0__clkbuf_3
XFILLER_7_398 VDD VDD VSS VSS gf180mcu_fd_sc_mcu7t5v0__fill_2
XFILLER_97_136 VDD VDD VSS VSS gf180mcu_fd_sc_mcu7t5v0__fillcap_4
Xload_slew268 _1621_/S _1633_/S VDD VDD VSS VSS gf180mcu_fd_sc_mcu7t5v0__buf_3
XFILLER_66_512 VDD VDD VSS VSS gf180mcu_fd_sc_mcu7t5v0__fillcap_8
X_2152_ _2152_/D _1895_/RN _2152_/CLK _2152_/Q VDD VDD VSS VSS gf180mcu_fd_sc_mcu7t5v0__dffsnq_1
XFILLER_78_383 VDD VDD VSS VSS gf180mcu_fd_sc_mcu7t5v0__fill_2
X_2083_ _2083_/D _2108_/RN _2125_/CLK _2083_/Q VDD VDD VSS VSS gf180mcu_fd_sc_mcu7t5v0__dffrnq_1
X_1103_ _2092_/Q _2168_/Q _1106_/A2 VDD VDD VSS VSS gf180mcu_fd_sc_mcu7t5v0__nand2_1
XFILLER_93_342 VDD VDD VSS VSS gf180mcu_fd_sc_mcu7t5v0__fillcap_8
X_1034_ _1020_/Z _1026_/Z _1032_/Z _1033_/Z _1039_/A1 VDD VDD VSS VSS gf180mcu_fd_sc_mcu7t5v0__nor4_1
XFILLER_21_158 VDD VDD VSS VSS gf180mcu_fd_sc_mcu7t5v0__fillcap_8
X_1936_ _1936_/D _2031_/RN _2000_/CLK _1936_/Q VDD VDD VSS VSS gf180mcu_fd_sc_mcu7t5v0__dffrnq_1
X_1867_ _1867_/D _1887_/RN _2171_/CLK _1867_/Q VDD VDD VSS VSS gf180mcu_fd_sc_mcu7t5v0__dffrnq_1
X_1798_ _1799_/C _1798_/A2 _1798_/A3 _1800_/A2 VDD VDD VSS VSS gf180mcu_fd_sc_mcu7t5v0__nand3_1
Xmax_cap530 _1681_/S _1682_/S VDD VDD VSS VSS gf180mcu_fd_sc_mcu7t5v0__clkbuf_2
Xinput82 cfg_tx_bytes_left_i[7] input82/Z VDD VDD VSS VSS gf180mcu_fd_sc_mcu7t5v0__dlyb_1
Xinput71 cfg_tx_bytes_left_i[11] input71/Z VDD VDD VSS VSS gf180mcu_fd_sc_mcu7t5v0__dlyb_1
Xinput60 cfg_rx_curr_addr_i[3] input60/Z VDD VDD VSS VSS gf180mcu_fd_sc_mcu7t5v0__dlyb_1
Xmax_cap552 _1919_/RN _1954_/RN VDD VDD VSS VSS gf180mcu_fd_sc_mcu7t5v0__buf_2
Xmax_cap541 _1433_/B _1444_/S VDD VDD VSS VSS gf180mcu_fd_sc_mcu7t5v0__dlyb_1
Xinput93 cfg_tx_curr_addr_i[6] input93/Z VDD VDD VSS VSS gf180mcu_fd_sc_mcu7t5v0__dlyb_1
XFILLER_89_626 VDD VDD VSS VSS gf180mcu_fd_sc_mcu7t5v0__fillcap_4
XTAP_TAPCELL_ROW_55_735 VDD VSS gf180mcu_fd_sc_mcu7t5v0__filltie
XFILLER_84_375 VDD VDD VSS VSS gf180mcu_fd_sc_mcu7t5v0__fillcap_8
XFILLER_25_486 VDD VDD VSS VSS gf180mcu_fd_sc_mcu7t5v0__fillcap_4
XFILLER_40_401 VDD VDD VSS VSS gf180mcu_fd_sc_mcu7t5v0__fill_1
XFILLER_52_272 VDD VDD VSS VSS gf180mcu_fd_sc_mcu7t5v0__fillcap_8
XTAP_TAPCELL_ROW_10_304 VDD VSS gf180mcu_fd_sc_mcu7t5v0__filltie
XFILLER_48_512 VDD VDD VSS VSS gf180mcu_fd_sc_mcu7t5v0__fillcap_8
XFILLER_35_228 VDD VDD VSS VSS gf180mcu_fd_sc_mcu7t5v0__fillcap_8
XFILLER_90_312 VDD VDD VSS VSS gf180mcu_fd_sc_mcu7t5v0__fill_2
XFILLER_75_397 VDD VDD VSS VSS gf180mcu_fd_sc_mcu7t5v0__fillcap_8
XFILLER_73_72 VDD VDD VSS VSS gf180mcu_fd_sc_mcu7t5v0__fillcap_8
X_1721_ _1718_/S _2062_/Q _1722_/B VDD VDD VSS VSS gf180mcu_fd_sc_mcu7t5v0__nand2_1
X_1652_ _2022_/Q input31/Z _1652_/S _2022_/D VDD VDD VSS VSS gf180mcu_fd_sc_mcu7t5v0__mux2_2
X_1583_ _1648_/A2 input33/Z _1328_/B _1583_/A4 _1583_/ZN VDD VDD VSS VSS gf180mcu_fd_sc_mcu7t5v0__nor4_1
X_2135_ _2135_/D _2139_/RN _2138_/CLK _2135_/Q VDD VDD VSS VSS gf180mcu_fd_sc_mcu7t5v0__dffrnq_1
XFILLER_39_556 VDD VDD VSS VSS gf180mcu_fd_sc_mcu7t5v0__fillcap_4
XFILLER_66_397 VDD VDD VSS VSS gf180mcu_fd_sc_mcu7t5v0__fillcap_16
X_2066_ _2066_/D _2081_/RN clkload9/I _2066_/Q VDD VDD VSS VSS gf180mcu_fd_sc_mcu7t5v0__dffrnq_1
X_1017_ _1000_/Z _1017_/A2 _1821_/A2 _1474_/B _1017_/C _1018_/B VDD VDD VSS VSS gf180mcu_fd_sc_mcu7t5v0__aoi221_1
XTAP_TAPCELL_ROW_52_705 VDD VSS gf180mcu_fd_sc_mcu7t5v0__filltie
XFILLER_81_378 VDD VDD VSS VSS gf180mcu_fd_sc_mcu7t5v0__fillcap_32
XFILLER_41_209 VDD VDD VSS VSS gf180mcu_fd_sc_mcu7t5v0__fill_1
XTAP_TAPCELL_ROW_60_782 VDD VSS gf180mcu_fd_sc_mcu7t5v0__filltie
X_1919_ _1919_/D _1919_/RN _1955_/CLK _1919_/Q VDD VDD VSS VSS gf180mcu_fd_sc_mcu7t5v0__dffrnq_1
XFILLER_89_445 VDD VDD VSS VSS gf180mcu_fd_sc_mcu7t5v0__fillcap_32
XFILLER_89_489 VDD VDD VSS VSS gf180mcu_fd_sc_mcu7t5v0__fill_1
XFILLER_77_629 VDD VDD VSS VSS gf180mcu_fd_sc_mcu7t5v0__fill_1
XTAP_TAPCELL_ROW_68_860 VDD VSS gf180mcu_fd_sc_mcu7t5v0__filltie
XFILLER_27_76 VDD VDD VSS VSS gf180mcu_fd_sc_mcu7t5v0__fill_1
XFILLER_25_250 VDD VDD VSS VSS gf180mcu_fd_sc_mcu7t5v0__fillcap_8
XFILLER_72_378 VDD VDD VSS VSS gf180mcu_fd_sc_mcu7t5v0__fillcap_4
XFILLER_53_570 VDD VDD VSS VSS gf180mcu_fd_sc_mcu7t5v0__fillcap_4
XFILLER_9_438 VDD VDD VSS VSS gf180mcu_fd_sc_mcu7t5v0__fill_2
XFILLER_4_165 VDD VDD VSS VSS gf180mcu_fd_sc_mcu7t5v0__fill_2
XFILLER_4_198 VDD VDD VSS VSS gf180mcu_fd_sc_mcu7t5v0__fill_1
XTAP_TAPCELL_ROW_89_1062 VDD VSS gf180mcu_fd_sc_mcu7t5v0__filltie
XFILLER_48_375 VDD VDD VSS VSS gf180mcu_fd_sc_mcu7t5v0__fill_2
XFILLER_91_632 VDD VDD VSS VSS gf180mcu_fd_sc_mcu7t5v0__fillcap_32
XFILLER_63_334 VDD VDD VSS VSS gf180mcu_fd_sc_mcu7t5v0__fillcap_16
XFILLER_23_209 VDD VDD VSS VSS gf180mcu_fd_sc_mcu7t5v0__fill_1
XFILLER_63_378 VDD VDD VSS VSS gf180mcu_fd_sc_mcu7t5v0__fillcap_8
X_1704_ _1691_/C _1704_/A2 _2105_/Q _1705_/B VDD VDD VSS VSS gf180mcu_fd_sc_mcu7t5v0__oai21_1
X_1635_ _1648_/A1 _1328_/B _1673_/A2 input1/Z wire266/I VDD VDD VSS VSS gf180mcu_fd_sc_mcu7t5v0__nor4_1
X_1566_ _1945_/Q _1574_/I0 _1568_/S _1945_/D VDD VDD VSS VSS gf180mcu_fd_sc_mcu7t5v0__mux2_2
Xfanout417 _2129_/Q _1811_/A4 VDD VDD VSS VSS gf180mcu_fd_sc_mcu7t5v0__dlyb_1
Xfanout428 input4/Z _0907_/I VDD VDD VSS VSS gf180mcu_fd_sc_mcu7t5v0__dlyb_1
Xfanout439 _2020_/RN _2032_/RN VDD VDD VSS VSS gf180mcu_fd_sc_mcu7t5v0__buf_1
X_1497_ _1497_/A1 _1525_/A2 _1497_/B _1910_/D VDD VDD VSS VSS gf180mcu_fd_sc_mcu7t5v0__oai21_1
XFILLER_58_139 VDD VDD VSS VSS gf180mcu_fd_sc_mcu7t5v0__fillcap_16
X_2118_ _2118_/D _2123_/RN clkload8/I _2118_/Q VDD VDD VSS VSS gf180mcu_fd_sc_mcu7t5v0__dffrnq_1
XTAP_TAPCELL_ROW_65_830 VDD VSS gf180mcu_fd_sc_mcu7t5v0__filltie
X_2049_ _2049_/D _2188_/RN _2116_/CLK _2049_/Q VDD VDD VSS VSS gf180mcu_fd_sc_mcu7t5v0__dffrnq_1
XTAP_TAPCELL_ROW_37_565 VDD VSS gf180mcu_fd_sc_mcu7t5v0__filltie
XFILLER_35_570 VDD VDD VSS VSS gf180mcu_fd_sc_mcu7t5v0__fill_2
XFILLER_1_157 VDD VDD VSS VSS gf180mcu_fd_sc_mcu7t5v0__fill_1
XFILLER_49_139 VDD VDD VSS VSS gf180mcu_fd_sc_mcu7t5v0__fill_1
XFILLER_57_150 VDD VDD VSS VSS gf180mcu_fd_sc_mcu7t5v0__fillcap_4
XFILLER_18_559 VDD VDD VSS VSS gf180mcu_fd_sc_mcu7t5v0__fill_2
XFILLER_73_632 VDD VDD VSS VSS gf180mcu_fd_sc_mcu7t5v0__fillcap_32
XFILLER_72_131 VDD VDD VSS VSS gf180mcu_fd_sc_mcu7t5v0__fill_2
XFILLER_45_356 VDD VDD VSS VSS gf180mcu_fd_sc_mcu7t5v0__fill_1
XFILLER_54_96 VDD VDD VSS VSS gf180mcu_fd_sc_mcu7t5v0__fill_2
XTAP_TAPCELL_ROW_71_888 VDD VSS gf180mcu_fd_sc_mcu7t5v0__filltie
XFILLER_41_562 VDD VDD VSS VSS gf180mcu_fd_sc_mcu7t5v0__fillcap_8
Xclkload16 _2138_/CLK clkload16/Z VDD VDD VSS VSS gf180mcu_fd_sc_mcu7t5v0__clkbuf_2
XFILLER_5_441 VDD VDD VSS VSS gf180mcu_fd_sc_mcu7t5v0__fillcap_32
X_1420_ _2060_/Q _1868_/Q _1423_/S _1868_/D VDD VDD VSS VSS gf180mcu_fd_sc_mcu7t5v0__mux2_2
X_1351_ _2044_/Q _1325_/Z _1395_/A2 input76/Z _1355_/A1 VDD VDD VSS VSS gf180mcu_fd_sc_mcu7t5v0__aoi22_1
XFILLER_1_680 VDD VDD VSS VSS gf180mcu_fd_sc_mcu7t5v0__fillcap_8
XTAP_TAPCELL_ROW_8_290 VDD VSS gf180mcu_fd_sc_mcu7t5v0__filltie
XFILLER_95_212 VDD VDD VSS VSS gf180mcu_fd_sc_mcu7t5v0__fillcap_64
XFILLER_68_426 VDD VDD VSS VSS gf180mcu_fd_sc_mcu7t5v0__fillcap_16
X_1282_ _1290_/A1 _1290_/A2 _1164_/I _1282_/A4 _1283_/A1 VDD VDD VSS VSS gf180mcu_fd_sc_mcu7t5v0__nand4_1
XTAP_TAPCELL_ROW_79_966 VDD VSS gf180mcu_fd_sc_mcu7t5v0__filltie
XFILLER_49_640 VDD VDD VSS VSS gf180mcu_fd_sc_mcu7t5v0__fillcap_4
XFILLER_83_418 VDD VDD VSS VSS gf180mcu_fd_sc_mcu7t5v0__fill_2
XFILLER_63_120 VDD VDD VSS VSS gf180mcu_fd_sc_mcu7t5v0__fillcap_4
XFILLER_24_507 VDD VDD VSS VSS gf180mcu_fd_sc_mcu7t5v0__fill_2
XTAP_TAPCELL_ROW_62_800 VDD VSS gf180mcu_fd_sc_mcu7t5v0__filltie
XFILLER_63_142 VDD VDD VSS VSS gf180mcu_fd_sc_mcu7t5v0__fillcap_32
XTAP_TAPCELL_ROW_34_535 VDD VSS gf180mcu_fd_sc_mcu7t5v0__filltie
X_0997_ _1956_/Q _1957_/Q _2127_/Q _2128_/D VDD VDD VSS VSS gf180mcu_fd_sc_mcu7t5v0__or3_1
XTAP_TAPCELL_ROW_98_1139 VDD VSS gf180mcu_fd_sc_mcu7t5v0__filltie
XFILLER_8_290 VDD VDD VSS VSS gf180mcu_fd_sc_mcu7t5v0__fill_1
X_1618_ _1990_/Q input6/Z _1633_/S _1990_/D VDD VDD VSS VSS gf180mcu_fd_sc_mcu7t5v0__mux2_2
X_1549_ _1549_/A1 _1550_/B _1550_/A2 _1555_/A1 VDD VDD VSS VSS gf180mcu_fd_sc_mcu7t5v0__nand3_1
Xfanout269 _1617_/ZN _1627_/S VDD VDD VSS VSS gf180mcu_fd_sc_mcu7t5v0__buf_1
XFILLER_67_492 VDD VDD VSS VSS gf180mcu_fd_sc_mcu7t5v0__fillcap_32
XFILLER_67_481 VDD VDD VSS VSS gf180mcu_fd_sc_mcu7t5v0__fillcap_8
XFILLER_55_632 VDD VDD VSS VSS gf180mcu_fd_sc_mcu7t5v0__fillcap_32
XFILLER_82_495 VDD VDD VSS VSS gf180mcu_fd_sc_mcu7t5v0__fill_2
XFILLER_54_164 VDD VDD VSS VSS gf180mcu_fd_sc_mcu7t5v0__fillcap_8
XFILLER_70_657 VDD VDD VSS VSS gf180mcu_fd_sc_mcu7t5v0__fillcap_8
XFILLER_23_562 VDD VDD VSS VSS gf180mcu_fd_sc_mcu7t5v0__fillcap_4
XFILLER_77_212 VDD VDD VSS VSS gf180mcu_fd_sc_mcu7t5v0__fill_2
XTAP_TAPCELL_ROW_5_260 VDD VSS gf180mcu_fd_sc_mcu7t5v0__filltie
XTAP_TAPCELL_ROW_76_936 VDD VSS gf180mcu_fd_sc_mcu7t5v0__filltie
XTAP_TAPCELL_ROW_86_1032 VDD VSS gf180mcu_fd_sc_mcu7t5v0__filltie
XFILLER_73_462 VDD VDD VSS VSS gf180mcu_fd_sc_mcu7t5v0__fillcap_16
XFILLER_45_142 VDD VDD VSS VSS gf180mcu_fd_sc_mcu7t5v0__fillcap_8
X_0920_ _2089_/Q _1146_/A1 VDD VDD VSS VSS gf180mcu_fd_sc_mcu7t5v0__clkinv_1
XTAP_TAPCELL_ROW_31_505 VDD VSS gf180mcu_fd_sc_mcu7t5v0__filltie
XFILLER_81_72 VDD VDD VSS VSS gf180mcu_fd_sc_mcu7t5v0__fillcap_16
XFILLER_60_167 VDD VDD VSS VSS gf180mcu_fd_sc_mcu7t5v0__fillcap_8
XFILLER_5_282 VDD VDD VSS VSS gf180mcu_fd_sc_mcu7t5v0__fill_2
X_1403_ _1403_/I _1403_/ZN VDD VDD VSS VSS gf180mcu_fd_sc_mcu7t5v0__clkinv_1
XPHY_EDGE_ROW_18_Right_18 VDD VSS gf180mcu_fd_sc_mcu7t5v0__endcap
X_1334_ input69/Z _1395_/A2 _1396_/A2 input39/Z _1349_/A1 VDD VDD VSS VSS gf180mcu_fd_sc_mcu7t5v0__aoi22_1
X_1265_ _1294_/A1 _1267_/A2 _1265_/A3 _1294_/A4 _2165_/D VDD VDD VSS VSS gf180mcu_fd_sc_mcu7t5v0__and4_1
XFILLER_68_267 VDD VDD VSS VSS gf180mcu_fd_sc_mcu7t5v0__fill_2
Xinput3 cfg_addr_i[2] input3/Z VDD VDD VSS VSS gf180mcu_fd_sc_mcu7t5v0__dlyb_1
XFILLER_36_131 VDD VDD VSS VSS gf180mcu_fd_sc_mcu7t5v0__fill_2
X_1196_ _1045_/B _1196_/A2 _1196_/ZN VDD VDD VSS VSS gf180mcu_fd_sc_mcu7t5v0__nand2_1
XTAP_TAPCELL_ROW_47_660 VDD VSS gf180mcu_fd_sc_mcu7t5v0__filltie
XFILLER_64_473 VDD VDD VSS VSS gf180mcu_fd_sc_mcu7t5v0__fill_2
XTAP_TAPCELL_ROW_19_395 VDD VSS gf180mcu_fd_sc_mcu7t5v0__filltie
XPHY_EDGE_ROW_27_Right_27 VDD VSS gf180mcu_fd_sc_mcu7t5v0__endcap
XFILLER_52_679 VDD VDD VSS VSS gf180mcu_fd_sc_mcu7t5v0__fill_2
XFILLER_51_167 VDD VDD VSS VSS gf180mcu_fd_sc_mcu7t5v0__fillcap_4
XFILLER_51_156 VDD VDD VSS VSS gf180mcu_fd_sc_mcu7t5v0__fill_2
XFILLER_20_510 VDD VDD VSS VSS gf180mcu_fd_sc_mcu7t5v0__fillcap_8
XFILLER_20_565 VDD VDD VSS VSS gf180mcu_fd_sc_mcu7t5v0__fillcap_4
XPHY_EDGE_ROW_36_Right_36 VDD VSS gf180mcu_fd_sc_mcu7t5v0__endcap
XFILLER_87_532 VDD VDD VSS VSS gf180mcu_fd_sc_mcu7t5v0__fill_2
XFILLER_59_278 VDD VDD VSS VSS gf180mcu_fd_sc_mcu7t5v0__fill_2
XFILLER_59_256 VDD VDD VSS VSS gf180mcu_fd_sc_mcu7t5v0__fill_2
XTAP_TAPCELL_ROW_2_230 VDD VSS gf180mcu_fd_sc_mcu7t5v0__filltie
XFILLER_74_237 VDD VDD VSS VSS gf180mcu_fd_sc_mcu7t5v0__fill_2
XFILLER_27_131 VDD VDD VSS VSS gf180mcu_fd_sc_mcu7t5v0__fillcap_8
XFILLER_27_142 VDD VDD VSS VSS gf180mcu_fd_sc_mcu7t5v0__fillcap_64
XFILLER_28_654 VDD VDD VSS VSS gf180mcu_fd_sc_mcu7t5v0__fill_2
XTAP_TAPCELL_ROW_73_906 VDD VSS gf180mcu_fd_sc_mcu7t5v0__filltie
XPHY_EDGE_ROW_45_Right_45 VDD VSS gf180mcu_fd_sc_mcu7t5v0__endcap
XFILLER_82_281 VDD VDD VSS VSS gf180mcu_fd_sc_mcu7t5v0__fill_2
XFILLER_70_454 VDD VDD VSS VSS gf180mcu_fd_sc_mcu7t5v0__fill_1
XTAP_TAPCELL_ROW_81_983 VDD VSS gf180mcu_fd_sc_mcu7t5v0__filltie
XFILLER_70_465 VDD VDD VSS VSS gf180mcu_fd_sc_mcu7t5v0__fillcap_4
Xwire401 wire401/I cfg_rx_size_o[5] VDD VDD VSS VSS gf180mcu_fd_sc_mcu7t5v0__clkbuf_3
Xwire412 wire412/I cfg_rx_size_o[0] VDD VDD VSS VSS gf180mcu_fd_sc_mcu7t5v0__clkbuf_3
Xclkbuf_4_7_0_periph_clk_i clkbuf_0_periph_clk_i/Z clkbuf_4_7_0_periph_clk_i/Z VDD
+ VDD VSS VSS gf180mcu_fd_sc_mcu7t5v0__clkbuf_2
XPHY_EDGE_ROW_54_Right_54 VDD VSS gf180mcu_fd_sc_mcu7t5v0__endcap
XTAP_TAPCELL_ROW_92_1091 VDD VSS gf180mcu_fd_sc_mcu7t5v0__filltie
XFILLER_76_61 VDD VDD VSS VSS gf180mcu_fd_sc_mcu7t5v0__fill_2
XFILLER_19_632 VDD VDD VSS VSS gf180mcu_fd_sc_mcu7t5v0__fillcap_16
X_1050_ _2152_/D _2151_/D _1424_/A1 VDD VDD VSS VSS gf180mcu_fd_sc_mcu7t5v0__nand2_1
XPHY_EDGE_ROW_63_Right_63 VDD VSS gf180mcu_fd_sc_mcu7t5v0__endcap
XFILLER_93_557 VDD VDD VSS VSS gf180mcu_fd_sc_mcu7t5v0__fill_2
XFILLER_46_451 VDD VDD VSS VSS gf180mcu_fd_sc_mcu7t5v0__fillcap_4
XFILLER_18_197 VDD VDD VSS VSS gf180mcu_fd_sc_mcu7t5v0__fill_2
XTAP_TAPCELL_ROW_44_630 VDD VSS gf180mcu_fd_sc_mcu7t5v0__filltie
XTAP_TAPCELL_ROW_16_365 VDD VSS gf180mcu_fd_sc_mcu7t5v0__filltie
XFILLER_21_329 VDD VDD VSS VSS gf180mcu_fd_sc_mcu7t5v0__fillcap_16
X_1952_ _1952_/D _1957_/RN _1952_/CLK _1952_/Q VDD VDD VSS VSS gf180mcu_fd_sc_mcu7t5v0__dffrnq_1
X_1883_ _1883_/D _1883_/RN _2058_/CLK _1883_/Q VDD VDD VSS VSS gf180mcu_fd_sc_mcu7t5v0__dffrnq_1
X_0903_ _2187_/D _0961_/A1 VDD VDD VSS VSS gf180mcu_fd_sc_mcu7t5v0__clkinv_1
XPHY_EDGE_ROW_72_Right_72 VDD VSS gf180mcu_fd_sc_mcu7t5v0__endcap
XFILLER_29_418 VDD VDD VSS VSS gf180mcu_fd_sc_mcu7t5v0__fill_2
X_1317_ input1/Z _1332_/A3 input5/Z _1336_/A2 VDD VDD VSS VSS gf180mcu_fd_sc_mcu7t5v0__nor3_1
XPHY_EDGE_ROW_81_Right_81 VDD VSS gf180mcu_fd_sc_mcu7t5v0__endcap
XFILLER_84_524 VDD VDD VSS VSS gf180mcu_fd_sc_mcu7t5v0__fill_1
XFILLER_69_598 VDD VDD VSS VSS gf180mcu_fd_sc_mcu7t5v0__fillcap_32
X_1248_ _1835_/B1 _1248_/A2 _2157_/D VDD VDD VSS VSS gf180mcu_fd_sc_mcu7t5v0__or2_1
XFILLER_71_207 VDD VDD VSS VSS gf180mcu_fd_sc_mcu7t5v0__fill_2
X_1179_ _1333_/A1 _1604_/A3 input4/Z _1179_/Z VDD VDD VSS VSS gf180mcu_fd_sc_mcu7t5v0__and3_1
XFILLER_52_443 VDD VDD VSS VSS gf180mcu_fd_sc_mcu7t5v0__fillcap_4
XFILLER_20_384 VDD VDD VSS VSS gf180mcu_fd_sc_mcu7t5v0__fill_1
XTAP_TAPCELL_ROW_50_688 VDD VSS gf180mcu_fd_sc_mcu7t5v0__filltie
XPHY_EDGE_ROW_90_Right_90 VDD VSS gf180mcu_fd_sc_mcu7t5v0__endcap
Xoutput170 _1982_/Q wire390/I VDD VDD VSS VSS gf180mcu_fd_sc_mcu7t5v0__buf_1
Xoutput192 _2026_/Q wire368/I VDD VDD VSS VSS gf180mcu_fd_sc_mcu7t5v0__buf_1
Xoutput181 _2030_/Q wire379/I VDD VDD VSS VSS gf180mcu_fd_sc_mcu7t5v0__buf_1
XTAP_TAPCELL_ROW_58_766 VDD VSS gf180mcu_fd_sc_mcu7t5v0__filltie
XFILLER_75_557 VDD VDD VSS VSS gf180mcu_fd_sc_mcu7t5v0__fill_2
XTAP_TAPCELL_ROW_83_1002 VDD VSS gf180mcu_fd_sc_mcu7t5v0__filltie
XFILLER_90_527 VDD VDD VSS VSS gf180mcu_fd_sc_mcu7t5v0__fillcap_8
XFILLER_83_590 VDD VDD VSS VSS gf180mcu_fd_sc_mcu7t5v0__fillcap_8
XTAP_TAPCELL_ROW_41_600 VDD VSS gf180mcu_fd_sc_mcu7t5v0__filltie
XFILLER_43_454 VDD VDD VSS VSS gf180mcu_fd_sc_mcu7t5v0__fill_1
XFILLER_30_148 VDD VDD VSS VSS gf180mcu_fd_sc_mcu7t5v0__fillcap_16
XTAP_TAPCELL_ROW_13_335 VDD VSS gf180mcu_fd_sc_mcu7t5v0__filltie
Xwire231 _1451_/S _1453_/S VDD VDD VSS VSS gf180mcu_fd_sc_mcu7t5v0__dlyb_1
Xwire242 wire242/I cfg_data_o[2] VDD VDD VSS VSS gf180mcu_fd_sc_mcu7t5v0__clkbuf_3
Xwire286 wire286/I data_rx_o[7] VDD VDD VSS VSS gf180mcu_fd_sc_mcu7t5v0__clkbuf_3
Xwire297 wire297/I cfg_data_o[28] VDD VDD VSS VSS gf180mcu_fd_sc_mcu7t5v0__clkbuf_3
X_2151_ _2151_/D _2151_/RN _2153_/CLK _2151_/Q VDD VDD VSS VSS gf180mcu_fd_sc_mcu7t5v0__dffrnq_1
XFILLER_66_524 VDD VDD VSS VSS gf180mcu_fd_sc_mcu7t5v0__fill_1
X_2082_ _2082_/D _2082_/RN _2082_/CLK _2082_/Q VDD VDD VSS VSS gf180mcu_fd_sc_mcu7t5v0__dffrnq_1
X_1102_ _2092_/Q _2168_/Q _1102_/Z VDD VDD VSS VSS gf180mcu_fd_sc_mcu7t5v0__or2_1
X_1033_ _2093_/Q _2138_/Q _1033_/Z VDD VDD VSS VSS gf180mcu_fd_sc_mcu7t5v0__xor2_1
XFILLER_34_443 VDD VDD VSS VSS gf180mcu_fd_sc_mcu7t5v0__fill_2
XTAP_TAPCELL_ROW_29_490 VDD VSS gf180mcu_fd_sc_mcu7t5v0__filltie
XFILLER_81_549 VDD VDD VSS VSS gf180mcu_fd_sc_mcu7t5v0__fill_2
XFILLER_22_605 VDD VDD VSS VSS gf180mcu_fd_sc_mcu7t5v0__fill_2
X_1935_ _1935_/D _2082_/RN _2082_/CLK _1935_/Q VDD VDD VSS VSS gf180mcu_fd_sc_mcu7t5v0__dffrnq_1
X_1866_ _1866_/D _1887_/RN _1887_/CLK _1866_/Q VDD VDD VSS VSS gf180mcu_fd_sc_mcu7t5v0__dffrnq_1
X_1797_ _1813_/A1 _1815_/B2 _1916_/Q _1798_/A3 VDD VDD VSS VSS gf180mcu_fd_sc_mcu7t5v0__nand3_1
Xinput50 cfg_rx_bytes_left_i[5] input50/Z VDD VDD VSS VSS gf180mcu_fd_sc_mcu7t5v0__dlyb_1
Xinput72 cfg_tx_bytes_left_i[12] input72/Z VDD VDD VSS VSS gf180mcu_fd_sc_mcu7t5v0__dlyb_1
Xinput61 cfg_rx_curr_addr_i[4] input61/Z VDD VDD VSS VSS gf180mcu_fd_sc_mcu7t5v0__dlyb_1
Xmax_cap553 _2101_/RN _2187_/RN VDD VDD VSS VSS gf180mcu_fd_sc_mcu7t5v0__buf_2
Xmax_cap542 _1873_/RN _1886_/RN VDD VDD VSS VSS gf180mcu_fd_sc_mcu7t5v0__buf_2
Xmax_cap531 _1678_/S _1681_/S VDD VDD VSS VSS gf180mcu_fd_sc_mcu7t5v0__clkbuf_1
Xinput94 cfg_tx_curr_addr_i[7] input94/Z VDD VDD VSS VSS gf180mcu_fd_sc_mcu7t5v0__dlyb_1
Xinput83 cfg_tx_bytes_left_i[8] input83/Z VDD VDD VSS VSS gf180mcu_fd_sc_mcu7t5v0__dlyb_1
Xclkbuf_5_5__f_periph_clk_i clkbuf_4_2_0_periph_clk_i/Z _2188_/CLK VDD VDD VSS VSS
+ gf180mcu_fd_sc_mcu7t5v0__clkbuf_16
XFILLER_69_395 VDD VDD VSS VSS gf180mcu_fd_sc_mcu7t5v0__fillcap_4
XFILLER_69_384 VDD VDD VSS VSS gf180mcu_fd_sc_mcu7t5v0__fillcap_4
XFILLER_57_546 VDD VDD VSS VSS gf180mcu_fd_sc_mcu7t5v0__fillcap_8
XFILLER_84_387 VDD VDD VSS VSS gf180mcu_fd_sc_mcu7t5v0__fillcap_64
XFILLER_16_23 VDD VDD VSS VSS gf180mcu_fd_sc_mcu7t5v0__fillcap_8
XTAP_TAPCELL_ROW_55_736 VDD VSS gf180mcu_fd_sc_mcu7t5v0__filltie
XPHY_EDGE_ROW_0_Right_0 VDD VSS gf180mcu_fd_sc_mcu7t5v0__endcap
XFILLER_80_593 VDD VDD VSS VSS gf180mcu_fd_sc_mcu7t5v0__fill_2
XFILLER_52_295 VDD VDD VSS VSS gf180mcu_fd_sc_mcu7t5v0__fillcap_8
XFILLER_52_284 VDD VDD VSS VSS gf180mcu_fd_sc_mcu7t5v0__fill_1
XFILLER_40_457 VDD VDD VSS VSS gf180mcu_fd_sc_mcu7t5v0__fillcap_16
XTAP_TAPCELL_ROW_10_305 VDD VSS gf180mcu_fd_sc_mcu7t5v0__filltie
XFILLER_20_170 VDD VDD VSS VSS gf180mcu_fd_sc_mcu7t5v0__fillcap_4
XFILLER_32_77 VDD VDD VSS VSS gf180mcu_fd_sc_mcu7t5v0__fillcap_4
XFILLER_4_358 VDD VDD VSS VSS gf180mcu_fd_sc_mcu7t5v0__fill_2
XFILLER_4_336 VDD VDD VSS VSS gf180mcu_fd_sc_mcu7t5v0__fill_2
XFILLER_79_137 VDD VDD VSS VSS gf180mcu_fd_sc_mcu7t5v0__fill_2
XFILLER_94_107 VDD VDD VSS VSS gf180mcu_fd_sc_mcu7t5v0__fillcap_64
XFILLER_48_535 VDD VDD VSS VSS gf180mcu_fd_sc_mcu7t5v0__fill_1
XFILLER_48_524 VDD VDD VSS VSS gf180mcu_fd_sc_mcu7t5v0__fill_1
XFILLER_75_365 VDD VDD VSS VSS gf180mcu_fd_sc_mcu7t5v0__fillcap_32
XFILLER_16_432 VDD VDD VSS VSS gf180mcu_fd_sc_mcu7t5v0__fillcap_4
XFILLER_90_357 VDD VDD VSS VSS gf180mcu_fd_sc_mcu7t5v0__fillcap_8
XFILLER_16_454 VDD VDD VSS VSS gf180mcu_fd_sc_mcu7t5v0__fill_1
XFILLER_16_465 VDD VDD VSS VSS gf180mcu_fd_sc_mcu7t5v0__fill_1
XFILLER_31_413 VDD VDD VSS VSS gf180mcu_fd_sc_mcu7t5v0__fillcap_4
XTAP_TAPCELL_ROW_26_460 VDD VSS gf180mcu_fd_sc_mcu7t5v0__filltie
XFILLER_12_693 VDD VDD VSS VSS gf180mcu_fd_sc_mcu7t5v0__fill_1
X_1720_ _1738_/A1 _2063_/Q _2102_/Q _1722_/A3 VDD VDD VSS VSS gf180mcu_fd_sc_mcu7t5v0__oai21_1
X_1651_ _2021_/Q input28/Z _1652_/S _2021_/D VDD VDD VSS VSS gf180mcu_fd_sc_mcu7t5v0__mux2_2
X_1582_ _1582_/A1 _1582_/A2 _1582_/A3 _1957_/D VDD VDD VSS VSS gf180mcu_fd_sc_mcu7t5v0__nand3_1
XFILLER_98_70 VDD VDD VSS VSS gf180mcu_fd_sc_mcu7t5v0__fillcap_32
XFILLER_79_682 VDD VDD VSS VSS gf180mcu_fd_sc_mcu7t5v0__fillcap_8
XFILLER_66_321 VDD VDD VSS VSS gf180mcu_fd_sc_mcu7t5v0__fill_1
X_2134_ _2134_/D _2136_/RN _2134_/CLK _2134_/Q VDD VDD VSS VSS gf180mcu_fd_sc_mcu7t5v0__dffrnq_1
XFILLER_66_354 VDD VDD VSS VSS gf180mcu_fd_sc_mcu7t5v0__fillcap_4
XFILLER_54_527 VDD VDD VSS VSS gf180mcu_fd_sc_mcu7t5v0__fillcap_16
XFILLER_19_292 VDD VDD VSS VSS gf180mcu_fd_sc_mcu7t5v0__fill_1
X_2065_ _2065_/D _2067_/RN _2158_/CLK _2065_/Q VDD VDD VSS VSS gf180mcu_fd_sc_mcu7t5v0__dffrnq_1
X_1016_ _1821_/C _1789_/A2 _1016_/B _1017_/C VDD VDD VSS VSS gf180mcu_fd_sc_mcu7t5v0__aoi21_1
XTAP_TAPCELL_ROW_52_706 VDD VSS gf180mcu_fd_sc_mcu7t5v0__filltie
XFILLER_22_457 VDD VDD VSS VSS gf180mcu_fd_sc_mcu7t5v0__fillcap_8
XTAP_TAPCELL_ROW_60_783 VDD VSS gf180mcu_fd_sc_mcu7t5v0__filltie
X_1918_ _1918_/D _1918_/RN _1951_/CLK _1918_/Q VDD VDD VSS VSS gf180mcu_fd_sc_mcu7t5v0__dffrnq_1
X_1849_ _1971_/Q _2096_/Q _1849_/S _2096_/D VDD VDD VSS VSS gf180mcu_fd_sc_mcu7t5v0__mux2_2
XFILLER_76_107 VDD VDD VSS VSS gf180mcu_fd_sc_mcu7t5v0__fillcap_64
XTAP_TAPCELL_ROW_68_861 VDD VSS gf180mcu_fd_sc_mcu7t5v0__filltie
XFILLER_13_413 VDD VDD VSS VSS gf180mcu_fd_sc_mcu7t5v0__fillcap_4
XFILLER_25_262 VDD VDD VSS VSS gf180mcu_fd_sc_mcu7t5v0__fill_2
XFILLER_43_10 VDD VDD VSS VSS gf180mcu_fd_sc_mcu7t5v0__fill_1
XTAP_TAPCELL_ROW_23_430 VDD VSS gf180mcu_fd_sc_mcu7t5v0__filltie
XFILLER_43_87 VDD VDD VSS VSS gf180mcu_fd_sc_mcu7t5v0__fillcap_16
XFILLER_4_37 VDD VDD VSS VSS gf180mcu_fd_sc_mcu7t5v0__fillcap_8
XFILLER_0_372 VDD VDD VSS VSS gf180mcu_fd_sc_mcu7t5v0__fill_2
XFILLER_36_527 VDD VDD VSS VSS gf180mcu_fd_sc_mcu7t5v0__fill_2
XFILLER_76_663 VDD VDD VSS VSS gf180mcu_fd_sc_mcu7t5v0__fill_2
XFILLER_48_387 VDD VDD VSS VSS gf180mcu_fd_sc_mcu7t5v0__fillcap_4
XFILLER_91_688 VDD VDD VSS VSS gf180mcu_fd_sc_mcu7t5v0__fillcap_4
XFILLER_31_276 VDD VDD VSS VSS gf180mcu_fd_sc_mcu7t5v0__fillcap_4
X_1703_ _1754_/A2 _2053_/Q _1703_/B _1703_/C _1705_/A2 VDD VDD VSS VSS gf180mcu_fd_sc_mcu7t5v0__oai211_1
X_1634_ input6/Z _2006_/Q _1634_/S _2006_/D VDD VDD VSS VSS gf180mcu_fd_sc_mcu7t5v0__mux2_2
X_1565_ _1944_/Q _1573_/I0 _1565_/S _1944_/D VDD VDD VSS VSS gf180mcu_fd_sc_mcu7t5v0__mux2_2
Xfanout418 _2069_/Q _1756_/A1 VDD VDD VSS VSS gf180mcu_fd_sc_mcu7t5v0__dlyb_1
Xfanout429 input4/Z _1191_/A1 VDD VDD VSS VSS gf180mcu_fd_sc_mcu7t5v0__dlyb_1
X_1496_ _1511_/B _1470_/Z _1496_/A3 _1525_/A2 VDD VDD VSS VSS gf180mcu_fd_sc_mcu7t5v0__nand3_1
XFILLER_86_438 VDD VDD VSS VSS gf180mcu_fd_sc_mcu7t5v0__fillcap_16
XFILLER_58_107 VDD VDD VSS VSS gf180mcu_fd_sc_mcu7t5v0__fillcap_32
XFILLER_39_332 VDD VDD VSS VSS gf180mcu_fd_sc_mcu7t5v0__fill_2
X_2117_ _2117_/D _2117_/RN clkload1/I _2117_/Q VDD VDD VSS VSS gf180mcu_fd_sc_mcu7t5v0__dffrnq_1
XTAP_TAPCELL_ROW_65_831 VDD VSS gf180mcu_fd_sc_mcu7t5v0__filltie
XFILLER_66_195 VDD VDD VSS VSS gf180mcu_fd_sc_mcu7t5v0__fillcap_4
X_2048_ _2048_/D _0904_/I clkload2/I _2048_/Q VDD VDD VSS VSS gf180mcu_fd_sc_mcu7t5v0__dffrnq_1
XTAP_TAPCELL_ROW_37_566 VDD VSS gf180mcu_fd_sc_mcu7t5v0__filltie
XFILLER_81_176 VDD VDD VSS VSS gf180mcu_fd_sc_mcu7t5v0__fillcap_32
XTAP_TAPCELL_ROW_20_400 VDD VSS gf180mcu_fd_sc_mcu7t5v0__filltie
XFILLER_13_68 VDD VDD VSS VSS gf180mcu_fd_sc_mcu7t5v0__fill_2
XFILLER_1_125 VDD VDD VSS VSS gf180mcu_fd_sc_mcu7t5v0__fill_1
XFILLER_89_298 VDD VDD VSS VSS gf180mcu_fd_sc_mcu7t5v0__fill_2
XFILLER_89_276 VDD VDD VSS VSS gf180mcu_fd_sc_mcu7t5v0__fillcap_4
XFILLER_77_438 VDD VDD VSS VSS gf180mcu_fd_sc_mcu7t5v0__fillcap_8
XFILLER_58_663 VDD VDD VSS VSS gf180mcu_fd_sc_mcu7t5v0__fill_2
XFILLER_18_527 VDD VDD VSS VSS gf180mcu_fd_sc_mcu7t5v0__fillcap_4
XFILLER_57_195 VDD VDD VSS VSS gf180mcu_fd_sc_mcu7t5v0__fillcap_4
XFILLER_38_98 VDD VDD VSS VSS gf180mcu_fd_sc_mcu7t5v0__fillcap_4
XFILLER_33_508 VDD VDD VSS VSS gf180mcu_fd_sc_mcu7t5v0__fill_2
XFILLER_73_688 VDD VDD VSS VSS gf180mcu_fd_sc_mcu7t5v0__fillcap_4
XFILLER_26_560 VDD VDD VSS VSS gf180mcu_fd_sc_mcu7t5v0__fillcap_8
XFILLER_54_53 VDD VDD VSS VSS gf180mcu_fd_sc_mcu7t5v0__fillcap_4
XFILLER_26_593 VDD VDD VSS VSS gf180mcu_fd_sc_mcu7t5v0__fill_2
XTAP_TAPCELL_ROW_71_889 VDD VSS gf180mcu_fd_sc_mcu7t5v0__filltie
Xclkload17 _2130_/CLK clkload17/Z VDD VDD VSS VSS gf180mcu_fd_sc_mcu7t5v0__clkbuf_2
XFILLER_79_72 VDD VDD VSS VSS gf180mcu_fd_sc_mcu7t5v0__fillcap_16
XFILLER_79_61 VDD VDD VSS VSS gf180mcu_fd_sc_mcu7t5v0__fillcap_8
X_1350_ input58/Z _1393_/B1 _1392_/B1 input88/Z _2041_/Q _1350_/C2 _1356_/A1 VDD VDD
+ VSS VSS gf180mcu_fd_sc_mcu7t5v0__aoi222_1
XFILLER_68_416 VDD VDD VSS VSS gf180mcu_fd_sc_mcu7t5v0__fill_2
XFILLER_1_692 VDD VDD VSS VSS gf180mcu_fd_sc_mcu7t5v0__fill_2
X_1281_ _1281_/A1 _1281_/A2 _1281_/B _1282_/A4 VDD VDD VSS VSS gf180mcu_fd_sc_mcu7t5v0__oai21_1
XTAP_TAPCELL_ROW_8_291 VDD VSS gf180mcu_fd_sc_mcu7t5v0__filltie
XTAP_TAPCELL_ROW_79_967 VDD VSS gf180mcu_fd_sc_mcu7t5v0__filltie
XFILLER_36_313 VDD VDD VSS VSS gf180mcu_fd_sc_mcu7t5v0__fill_2
XTAP_TAPCELL_ROW_62_801 VDD VSS gf180mcu_fd_sc_mcu7t5v0__filltie
XTAP_TAPCELL_ROW_34_536 VDD VSS gf180mcu_fd_sc_mcu7t5v0__filltie
XFILLER_63_198 VDD VDD VSS VSS gf180mcu_fd_sc_mcu7t5v0__fill_2
XFILLER_51_349 VDD VDD VSS VSS gf180mcu_fd_sc_mcu7t5v0__fill_1
XFILLER_32_574 VDD VDD VSS VSS gf180mcu_fd_sc_mcu7t5v0__fillcap_16
X_0996_ _1937_/Q _0994_/Z _1936_/Q _1578_/A1 _0996_/C _1550_/A1 VDD VDD VSS VSS gf180mcu_fd_sc_mcu7t5v0__oai221_1
X_1617_ _1648_/A2 _1328_/B _0907_/I _0906_/I _1617_/ZN VDD VDD VSS VSS gf180mcu_fd_sc_mcu7t5v0__nor4_1
X_1548_ _1549_/A1 _1550_/A2 _1553_/A1 VDD VDD VSS VSS gf180mcu_fd_sc_mcu7t5v0__nand2_1
XFILLER_59_416 VDD VDD VSS VSS gf180mcu_fd_sc_mcu7t5v0__fillcap_4
X_1479_ _1479_/A1 _1479_/A2 _1904_/D VDD VDD VSS VSS gf180mcu_fd_sc_mcu7t5v0__nand2_1
Xfanout259 _1829_/A2 _1826_/A1 VDD VDD VSS VSS gf180mcu_fd_sc_mcu7t5v0__dlyb_1
XFILLER_86_279 VDD VDD VSS VSS gf180mcu_fd_sc_mcu7t5v0__fillcap_8
XFILLER_15_508 VDD VDD VSS VSS gf180mcu_fd_sc_mcu7t5v0__fillcap_32
XFILLER_55_688 VDD VDD VSS VSS gf180mcu_fd_sc_mcu7t5v0__fillcap_4
XFILLER_24_23 VDD VDD VSS VSS gf180mcu_fd_sc_mcu7t5v0__fillcap_8
XFILLER_24_45 VDD VDD VSS VSS gf180mcu_fd_sc_mcu7t5v0__fillcap_4
XFILLER_2_445 VDD VDD VSS VSS gf180mcu_fd_sc_mcu7t5v0__fillcap_8
Xclkbuf_4_15_0_periph_clk_i clkbuf_0_periph_clk_i/Z clkbuf_4_15_0_periph_clk_i/Z VDD
+ VDD VSS VSS gf180mcu_fd_sc_mcu7t5v0__clkbuf_2
XFILLER_49_53 VDD VDD VSS VSS gf180mcu_fd_sc_mcu7t5v0__fill_1
XTAP_TAPCELL_ROW_5_261 VDD VSS gf180mcu_fd_sc_mcu7t5v0__filltie
XFILLER_77_279 VDD VDD VSS VSS gf180mcu_fd_sc_mcu7t5v0__fill_1
XTAP_TAPCELL_ROW_76_937 VDD VSS gf180mcu_fd_sc_mcu7t5v0__filltie
XTAP_TAPCELL_ROW_86_1033 VDD VSS gf180mcu_fd_sc_mcu7t5v0__filltie
XFILLER_85_290 VDD VDD VSS VSS gf180mcu_fd_sc_mcu7t5v0__fillcap_4
XFILLER_46_655 VDD VDD VSS VSS gf180mcu_fd_sc_mcu7t5v0__fill_1
XFILLER_18_379 VDD VDD VSS VSS gf180mcu_fd_sc_mcu7t5v0__fillcap_4
XFILLER_45_198 VDD VDD VSS VSS gf180mcu_fd_sc_mcu7t5v0__fillcap_8
XTAP_TAPCELL_ROW_31_506 VDD VSS gf180mcu_fd_sc_mcu7t5v0__filltie
X_1402_ input74/Z _1404_/A2 _1404_/B1 input44/Z _1403_/I VDD VDD VSS VSS gf180mcu_fd_sc_mcu7t5v0__aoi22_1
X_1333_ _1333_/A1 _1376_/A1 _1333_/Z VDD VDD VSS VSS gf180mcu_fd_sc_mcu7t5v0__and2_1
X_1264_ _1270_/A1 _1270_/A4 _1265_/A3 VDD VDD VSS VSS gf180mcu_fd_sc_mcu7t5v0__nand2_1
Xinput4 cfg_addr_i[3] input4/Z VDD VDD VSS VSS gf180mcu_fd_sc_mcu7t5v0__dlyb_1
X_1195_ _1195_/A1 _1975_/Q _1195_/A3 _1195_/A4 _1195_/Z VDD VDD VSS VSS gf180mcu_fd_sc_mcu7t5v0__and4_1
XFILLER_64_430 VDD VDD VSS VSS gf180mcu_fd_sc_mcu7t5v0__fillcap_16
XFILLER_24_327 VDD VDD VSS VSS gf180mcu_fd_sc_mcu7t5v0__fill_1
XTAP_TAPCELL_ROW_47_661 VDD VSS gf180mcu_fd_sc_mcu7t5v0__filltie
XFILLER_64_496 VDD VDD VSS VSS gf180mcu_fd_sc_mcu7t5v0__fillcap_16
XTAP_TAPCELL_ROW_19_396 VDD VSS gf180mcu_fd_sc_mcu7t5v0__filltie
XFILLER_91_282 VDD VDD VSS VSS gf180mcu_fd_sc_mcu7t5v0__fillcap_64
XFILLER_51_146 VDD VDD VSS VSS gf180mcu_fd_sc_mcu7t5v0__fill_1
XFILLER_51_135 VDD VDD VSS VSS gf180mcu_fd_sc_mcu7t5v0__fillcap_4
XFILLER_32_382 VDD VDD VSS VSS gf180mcu_fd_sc_mcu7t5v0__fill_2
XFILLER_60_691 VDD VDD VSS VSS gf180mcu_fd_sc_mcu7t5v0__fill_2
X_0979_ _1604_/A3 _0907_/I _1583_/A4 VDD VDD VSS VSS gf180mcu_fd_sc_mcu7t5v0__nand2_1
XFILLER_3_209 VDD VDD VSS VSS gf180mcu_fd_sc_mcu7t5v0__fill_1
XFILLER_87_500 VDD VDD VSS VSS gf180mcu_fd_sc_mcu7t5v0__fillcap_32
XFILLER_87_555 VDD VDD VSS VSS gf180mcu_fd_sc_mcu7t5v0__fillcap_4
XFILLER_87_566 VDD VDD VSS VSS gf180mcu_fd_sc_mcu7t5v0__fill_2
XFILLER_47_408 VDD VDD VSS VSS gf180mcu_fd_sc_mcu7t5v0__fill_1
XFILLER_19_67 VDD VDD VSS VSS gf180mcu_fd_sc_mcu7t5v0__fill_2
XTAP_TAPCELL_ROW_2_231 VDD VSS gf180mcu_fd_sc_mcu7t5v0__filltie
XTAP_TAPCELL_ROW_73_907 VDD VSS gf180mcu_fd_sc_mcu7t5v0__filltie
XFILLER_55_485 VDD VDD VSS VSS gf180mcu_fd_sc_mcu7t5v0__fillcap_4
XFILLER_42_102 VDD VDD VSS VSS gf180mcu_fd_sc_mcu7t5v0__fill_2
XFILLER_15_338 VDD VDD VSS VSS gf180mcu_fd_sc_mcu7t5v0__fill_2
XTAP_TAPCELL_ROW_81_984 VDD VSS gf180mcu_fd_sc_mcu7t5v0__filltie
XFILLER_11_500 VDD VDD VSS VSS gf180mcu_fd_sc_mcu7t5v0__fillcap_4
XFILLER_11_555 VDD VDD VSS VSS gf180mcu_fd_sc_mcu7t5v0__fillcap_4
Xwire402 wire402/I cfg_rx_size_o[4] VDD VDD VSS VSS gf180mcu_fd_sc_mcu7t5v0__clkbuf_3
Xwire413 wire413/I cfg_rx_en_o VDD VDD VSS VSS gf180mcu_fd_sc_mcu7t5v0__clkbuf_3
XPHY_EDGE_ROW_29_Left_128 VDD VSS gf180mcu_fd_sc_mcu7t5v0__endcap
XFILLER_65_216 VDD VDD VSS VSS gf180mcu_fd_sc_mcu7t5v0__fill_2
XFILLER_73_271 VDD VDD VSS VSS gf180mcu_fd_sc_mcu7t5v0__fill_1
XFILLER_33_135 VDD VDD VSS VSS gf180mcu_fd_sc_mcu7t5v0__fillcap_4
XTAP_TAPCELL_ROW_44_631 VDD VSS gf180mcu_fd_sc_mcu7t5v0__filltie
XPHY_EDGE_ROW_1_Left_100 VDD VSS gf180mcu_fd_sc_mcu7t5v0__endcap
XFILLER_73_282 VDD VDD VSS VSS gf180mcu_fd_sc_mcu7t5v0__fillcap_32
XTAP_TAPCELL_ROW_16_366 VDD VSS gf180mcu_fd_sc_mcu7t5v0__filltie
XPHY_EDGE_ROW_38_Left_137 VDD VSS gf180mcu_fd_sc_mcu7t5v0__endcap
XFILLER_61_488 VDD VDD VSS VSS gf180mcu_fd_sc_mcu7t5v0__fill_2
X_1951_ _1951_/D _1951_/RN _1951_/CLK _1951_/Q VDD VDD VSS VSS gf180mcu_fd_sc_mcu7t5v0__dffrnq_1
X_1882_ _1882_/D _1883_/RN _2057_/CLK _1882_/Q VDD VDD VSS VSS gf180mcu_fd_sc_mcu7t5v0__dffrnq_1
X_0902_ _2181_/D _0960_/A1 VDD VDD VSS VSS gf180mcu_fd_sc_mcu7t5v0__clkinv_1
XFILLER_51_2 VDD VDD VSS VSS gf180mcu_fd_sc_mcu7t5v0__fillcap_64
XPHY_EDGE_ROW_47_Left_146 VDD VSS gf180mcu_fd_sc_mcu7t5v0__endcap
XFILLER_88_308 VDD VDD VSS VSS gf180mcu_fd_sc_mcu7t5v0__fillcap_4
X_1316_ _2068_/Q _2069_/Q _1316_/B _1316_/ZN VDD VDD VSS VSS gf180mcu_fd_sc_mcu7t5v0__oai21_1
XFILLER_69_577 VDD VDD VSS VSS gf180mcu_fd_sc_mcu7t5v0__fillcap_4
XFILLER_56_238 VDD VDD VSS VSS gf180mcu_fd_sc_mcu7t5v0__fillcap_4
X_1247_ _1247_/A1 _1247_/A2 _1246_/Z _2145_/D VDD VDD VSS VSS gf180mcu_fd_sc_mcu7t5v0__nor3_1
XFILLER_49_290 VDD VDD VSS VSS gf180mcu_fd_sc_mcu7t5v0__fill_1
XFILLER_37_474 VDD VDD VSS VSS gf180mcu_fd_sc_mcu7t5v0__fillcap_16
X_1178_ _1604_/A4 _1332_/A4 _1328_/B _0906_/I _1345_/A3 VDD VDD VSS VSS gf180mcu_fd_sc_mcu7t5v0__nor4_1
XPHY_EDGE_ROW_56_Left_155 VDD VSS gf180mcu_fd_sc_mcu7t5v0__endcap
XFILLER_92_591 VDD VDD VSS VSS gf180mcu_fd_sc_mcu7t5v0__fillcap_4
XFILLER_64_271 VDD VDD VSS VSS gf180mcu_fd_sc_mcu7t5v0__fill_2
XTAP_TAPCELL_ROW_50_689 VDD VSS gf180mcu_fd_sc_mcu7t5v0__filltie
XFILLER_21_68 VDD VDD VSS VSS gf180mcu_fd_sc_mcu7t5v0__fill_2
XPHY_EDGE_ROW_65_Left_164 VDD VSS gf180mcu_fd_sc_mcu7t5v0__endcap
XFILLER_4_518 VDD VDD VSS VSS gf180mcu_fd_sc_mcu7t5v0__fillcap_4
Xoutput160 _1996_/Q wire400/I VDD VDD VSS VSS gf180mcu_fd_sc_mcu7t5v0__buf_1
Xoutput193 _2027_/Q wire367/I VDD VDD VSS VSS gf180mcu_fd_sc_mcu7t5v0__buf_1
Xoutput182 _2031_/Q wire378/I VDD VDD VSS VSS gf180mcu_fd_sc_mcu7t5v0__buf_1
Xoutput171 _1983_/Q wire389/I VDD VDD VSS VSS gf180mcu_fd_sc_mcu7t5v0__buf_1
XFILLER_87_352 VDD VDD VSS VSS gf180mcu_fd_sc_mcu7t5v0__fillcap_64
XFILLER_75_503 VDD VDD VSS VSS gf180mcu_fd_sc_mcu7t5v0__fillcap_16
XFILLER_47_227 VDD VDD VSS VSS gf180mcu_fd_sc_mcu7t5v0__fillcap_8
XTAP_TAPCELL_ROW_58_767 VDD VSS gf180mcu_fd_sc_mcu7t5v0__filltie
XPHY_EDGE_ROW_74_Left_173 VDD VSS gf180mcu_fd_sc_mcu7t5v0__endcap
XFILLER_90_517 VDD VDD VSS VSS gf180mcu_fd_sc_mcu7t5v0__fillcap_8
XFILLER_15_135 VDD VDD VSS VSS gf180mcu_fd_sc_mcu7t5v0__fillcap_4
XTAP_TAPCELL_ROW_83_1003 VDD VSS gf180mcu_fd_sc_mcu7t5v0__filltie
XFILLER_55_282 VDD VDD VSS VSS gf180mcu_fd_sc_mcu7t5v0__fillcap_32
XFILLER_43_422 VDD VDD VSS VSS gf180mcu_fd_sc_mcu7t5v0__fillcap_16
XFILLER_15_146 VDD VDD VSS VSS gf180mcu_fd_sc_mcu7t5v0__fill_2
XFILLER_30_116 VDD VDD VSS VSS gf180mcu_fd_sc_mcu7t5v0__fillcap_32
XTAP_TAPCELL_ROW_41_601 VDD VSS gf180mcu_fd_sc_mcu7t5v0__filltie
XFILLER_11_330 VDD VDD VSS VSS gf180mcu_fd_sc_mcu7t5v0__fillcap_8
XTAP_TAPCELL_ROW_13_336 VDD VSS gf180mcu_fd_sc_mcu7t5v0__filltie
XFILLER_11_352 VDD VDD VSS VSS gf180mcu_fd_sc_mcu7t5v0__fillcap_8
Xclkbuf_4_15_0_sys_clk_i clkbuf_0_sys_clk_i/Z clkbuf_4_15_0_sys_clk_i/Z VDD VDD VSS
+ VSS gf180mcu_fd_sc_mcu7t5v0__clkbuf_2
Xwire221 wire221/I cfg_data_o[0] VDD VDD VSS VSS gf180mcu_fd_sc_mcu7t5v0__clkbuf_3
Xwire243 wire243/I cfg_data_o[15] VDD VDD VSS VSS gf180mcu_fd_sc_mcu7t5v0__clkbuf_3
XPHY_EDGE_ROW_83_Left_182 VDD VSS gf180mcu_fd_sc_mcu7t5v0__endcap
XFILLER_7_334 VDD VDD VSS VSS gf180mcu_fd_sc_mcu7t5v0__fillcap_16
Xwire287 wire287/I data_rx_o[6] VDD VDD VSS VSS gf180mcu_fd_sc_mcu7t5v0__clkbuf_3
Xwire298 wire298/I cfg_data_o[27] VDD VDD VSS VSS gf180mcu_fd_sc_mcu7t5v0__clkbuf_3
XTAP_TAPCELL_ROW_94_1110 VDD VSS gf180mcu_fd_sc_mcu7t5v0__filltie
XFILLER_7_378 VDD VDD VSS VSS gf180mcu_fd_sc_mcu7t5v0__fillcap_16
XFILLER_87_72 VDD VDD VSS VSS gf180mcu_fd_sc_mcu7t5v0__fillcap_64
X_2150_ _2150_/D _2151_/RN _2152_/CLK _2150_/Q VDD VDD VSS VSS gf180mcu_fd_sc_mcu7t5v0__dffrnq_1
XPHY_EDGE_ROW_92_Left_191 VDD VSS gf180mcu_fd_sc_mcu7t5v0__endcap
X_2081_ _2081_/D _2081_/RN _2157_/CLK _2081_/Q VDD VDD VSS VSS gf180mcu_fd_sc_mcu7t5v0__dffrnq_1
X_1101_ _1101_/A1 _1098_/Z _1101_/B1 _1100_/Z _1108_/A3 VDD VDD VSS VSS gf180mcu_fd_sc_mcu7t5v0__aoi22_1
X_1032_ _2094_/Q _2139_/Q _1032_/Z VDD VDD VSS VSS gf180mcu_fd_sc_mcu7t5v0__xor2_1
XFILLER_53_208 VDD VDD VSS VSS gf180mcu_fd_sc_mcu7t5v0__fill_2
XFILLER_74_580 VDD VDD VSS VSS gf180mcu_fd_sc_mcu7t5v0__fill_2
XFILLER_46_271 VDD VDD VSS VSS gf180mcu_fd_sc_mcu7t5v0__fill_1
Xclkbuf_5_28__f_periph_clk_i clkbuf_4_14_0_periph_clk_i/Z _2095_/CLK VDD VDD VSS VSS
+ gf180mcu_fd_sc_mcu7t5v0__clkbuf_16
XTAP_TAPCELL_ROW_29_491 VDD VSS gf180mcu_fd_sc_mcu7t5v0__filltie
X_1934_ _1934_/D _2123_/RN _2082_/CLK _1934_/Q VDD VDD VSS VSS gf180mcu_fd_sc_mcu7t5v0__dffrnq_1
X_1865_ _1865_/D _2156_/RN _2182_/CLK _1865_/Q VDD VDD VSS VSS gf180mcu_fd_sc_mcu7t5v0__dffrnq_1
Xinput40 cfg_rx_bytes_left_i[10] input40/Z VDD VDD VSS VSS gf180mcu_fd_sc_mcu7t5v0__dlyb_1
X_1796_ _1815_/A1 _1924_/Q _1798_/A2 VDD VDD VSS VSS gf180mcu_fd_sc_mcu7t5v0__nand2_1
Xinput51 cfg_rx_bytes_left_i[6] input51/Z VDD VDD VSS VSS gf180mcu_fd_sc_mcu7t5v0__dlyb_1
Xinput73 cfg_tx_bytes_left_i[13] input73/Z VDD VDD VSS VSS gf180mcu_fd_sc_mcu7t5v0__dlyb_1
Xinput62 cfg_rx_curr_addr_i[5] input62/Z VDD VDD VSS VSS gf180mcu_fd_sc_mcu7t5v0__dlyb_1
Xmax_cap554 _2182_/RN _2185_/RN VDD VDD VSS VSS gf180mcu_fd_sc_mcu7t5v0__buf_2
Xmax_cap543 _1611_/S _1616_/S VDD VDD VSS VSS gf180mcu_fd_sc_mcu7t5v0__buf_2
Xmax_cap532 _1435_/S _1440_/S VDD VDD VSS VSS gf180mcu_fd_sc_mcu7t5v0__buf_2
Xinput95 cfg_tx_curr_addr_i[8] input95/Z VDD VDD VSS VSS gf180mcu_fd_sc_mcu7t5v0__dlyb_1
Xinput84 cfg_tx_bytes_left_i[9] input84/Z VDD VDD VSS VSS gf180mcu_fd_sc_mcu7t5v0__dlyb_1
XFILLER_69_352 VDD VDD VSS VSS gf180mcu_fd_sc_mcu7t5v0__fillcap_32
XFILLER_96_171 VDD VDD VSS VSS gf180mcu_fd_sc_mcu7t5v0__fillcap_4
XFILLER_57_558 VDD VDD VSS VSS gf180mcu_fd_sc_mcu7t5v0__fill_2
XFILLER_25_422 VDD VDD VSS VSS gf180mcu_fd_sc_mcu7t5v0__fillcap_8
XFILLER_37_282 VDD VDD VSS VSS gf180mcu_fd_sc_mcu7t5v0__fillcap_32
XTAP_TAPCELL_ROW_55_737 VDD VSS gf180mcu_fd_sc_mcu7t5v0__filltie
XFILLER_13_617 VDD VDD VSS VSS gf180mcu_fd_sc_mcu7t5v0__fillcap_8
XFILLER_25_466 VDD VDD VSS VSS gf180mcu_fd_sc_mcu7t5v0__fillcap_8
XFILLER_40_436 VDD VDD VSS VSS gf180mcu_fd_sc_mcu7t5v0__fillcap_8
XTAP_TAPCELL_ROW_10_306 VDD VSS gf180mcu_fd_sc_mcu7t5v0__filltie
XFILLER_88_661 VDD VDD VSS VSS gf180mcu_fd_sc_mcu7t5v0__fillcap_4
XFILLER_88_683 VDD VDD VSS VSS gf180mcu_fd_sc_mcu7t5v0__fill_2
XFILLER_75_322 VDD VDD VSS VSS gf180mcu_fd_sc_mcu7t5v0__fill_2
XFILLER_90_314 VDD VDD VSS VSS gf180mcu_fd_sc_mcu7t5v0__fill_1
XFILLER_90_325 VDD VDD VSS VSS gf180mcu_fd_sc_mcu7t5v0__fill_1
XFILLER_56_591 VDD VDD VSS VSS gf180mcu_fd_sc_mcu7t5v0__fillcap_4
XFILLER_43_230 VDD VDD VSS VSS gf180mcu_fd_sc_mcu7t5v0__fill_1
XTAP_TAPCELL_ROW_26_461 VDD VSS gf180mcu_fd_sc_mcu7t5v0__filltie
XFILLER_71_594 VDD VDD VSS VSS gf180mcu_fd_sc_mcu7t5v0__fillcap_8
XFILLER_12_661 VDD VDD VSS VSS gf180mcu_fd_sc_mcu7t5v0__fillcap_4
XFILLER_12_683 VDD VDD VSS VSS gf180mcu_fd_sc_mcu7t5v0__fillcap_8
X_1650_ _2020_/Q input17/Z _1652_/S _2020_/D VDD VDD VSS VSS gf180mcu_fd_sc_mcu7t5v0__mux2_2
XFILLER_7_142 VDD VDD VSS VSS gf180mcu_fd_sc_mcu7t5v0__fillcap_4
X_1581_ _1550_/B _1957_/Q _1956_/Q _1456_/B _1582_/A3 VDD VDD VSS VSS gf180mcu_fd_sc_mcu7t5v0__nand4_1
X_2133_ _2133_/D _2133_/RN _2133_/CLK _2133_/Q VDD VDD VSS VSS gf180mcu_fd_sc_mcu7t5v0__dffrnq_1
XFILLER_26_208 VDD VDD VSS VSS gf180mcu_fd_sc_mcu7t5v0__fill_2
XFILLER_19_282 VDD VDD VSS VSS gf180mcu_fd_sc_mcu7t5v0__fillcap_8
X_2064_ _2064_/D _2081_/RN _2158_/CLK _2064_/Q VDD VDD VSS VSS gf180mcu_fd_sc_mcu7t5v0__dffrnq_1
XFILLER_34_241 VDD VDD VSS VSS gf180mcu_fd_sc_mcu7t5v0__fillcap_4
X_1015_ _2125_/D _2122_/D _1016_/B VDD VDD VSS VSS gf180mcu_fd_sc_mcu7t5v0__nand2_1
XTAP_TAPCELL_ROW_52_707 VDD VSS gf180mcu_fd_sc_mcu7t5v0__filltie
XFILLER_34_263 VDD VDD VSS VSS gf180mcu_fd_sc_mcu7t5v0__fillcap_8
XFILLER_62_594 VDD VDD VSS VSS gf180mcu_fd_sc_mcu7t5v0__fill_1
XTAP_TAPCELL_ROW_60_784 VDD VSS gf180mcu_fd_sc_mcu7t5v0__filltie
X_1917_ _1917_/D _1918_/RN _1951_/CLK _1917_/Q VDD VDD VSS VSS gf180mcu_fd_sc_mcu7t5v0__dffrnq_1
X_1848_ _1970_/Q _2095_/Q _1848_/S _2095_/D VDD VDD VSS VSS gf180mcu_fd_sc_mcu7t5v0__mux2_2
X_1779_ _1826_/A1 _1829_/A3 _2074_/Q _1811_/A4 _1785_/C VDD VDD VSS VSS gf180mcu_fd_sc_mcu7t5v0__nand4_1
Xmax_cap340 _1306_/S1 _1311_/S1 VDD VDD VSS VSS gf180mcu_fd_sc_mcu7t5v0__clkbuf_2
XFILLER_89_414 VDD VDD VSS VSS gf180mcu_fd_sc_mcu7t5v0__fillcap_4
XFILLER_69_193 VDD VDD VSS VSS gf180mcu_fd_sc_mcu7t5v0__fillcap_8
XFILLER_69_182 VDD VDD VSS VSS gf180mcu_fd_sc_mcu7t5v0__fill_1
XTAP_TAPCELL_ROW_68_862 VDD VSS gf180mcu_fd_sc_mcu7t5v0__filltie
XFILLER_85_664 VDD VDD VSS VSS gf180mcu_fd_sc_mcu7t5v0__fillcap_16
XTAP_TAPCELL_ROW_23_431 VDD VSS gf180mcu_fd_sc_mcu7t5v0__filltie
XFILLER_75_174 VDD VDD VSS VSS gf180mcu_fd_sc_mcu7t5v0__fillcap_16
XFILLER_63_314 VDD VDD VSS VSS gf180mcu_fd_sc_mcu7t5v0__fillcap_8
XFILLER_31_200 VDD VDD VSS VSS gf180mcu_fd_sc_mcu7t5v0__fillcap_8
XFILLER_90_177 VDD VDD VSS VSS gf180mcu_fd_sc_mcu7t5v0__fillcap_64
XFILLER_8_440 VDD VDD VSS VSS gf180mcu_fd_sc_mcu7t5v0__fillcap_8
X_1702_ _1702_/A1 _1702_/A2 _1702_/B _2054_/D VDD VDD VSS VSS gf180mcu_fd_sc_mcu7t5v0__aoi21_1
X_1633_ _2005_/Q input12/Z _1633_/S _2005_/D VDD VDD VSS VSS gf180mcu_fd_sc_mcu7t5v0__mux2_2
X_1564_ _1943_/Q _1572_/I0 _1568_/S _1943_/D VDD VDD VSS VSS gf180mcu_fd_sc_mcu7t5v0__mux2_2
X_1495_ _1499_/A1 _1910_/Q _1497_/B VDD VDD VSS VSS gf180mcu_fd_sc_mcu7t5v0__nand2_1
Xfanout419 _2055_/Q _1691_/C VDD VDD VSS VSS gf180mcu_fd_sc_mcu7t5v0__dlyb_1
XFILLER_67_664 VDD VDD VSS VSS gf180mcu_fd_sc_mcu7t5v0__fillcap_16
X_2116_ _2116_/D _0904_/I _2116_/CLK _2116_/Q VDD VDD VSS VSS gf180mcu_fd_sc_mcu7t5v0__dffrnq_1
XTAP_TAPCELL_ROW_65_832 VDD VSS gf180mcu_fd_sc_mcu7t5v0__filltie
X_2047_ _2047_/D _2047_/RN _2116_/CLK _2047_/Q VDD VDD VSS VSS gf180mcu_fd_sc_mcu7t5v0__dffrnq_1
XTAP_TAPCELL_ROW_37_567 VDD VSS gf180mcu_fd_sc_mcu7t5v0__filltie
XFILLER_82_667 VDD VDD VSS VSS gf180mcu_fd_sc_mcu7t5v0__fillcap_16
XFILLER_10_406 VDD VDD VSS VSS gf180mcu_fd_sc_mcu7t5v0__fill_2
XFILLER_22_244 VDD VDD VSS VSS gf180mcu_fd_sc_mcu7t5v0__fill_1
XFILLER_13_36 VDD VDD VSS VSS gf180mcu_fd_sc_mcu7t5v0__fillcap_32
XTAP_TAPCELL_ROW_20_401 VDD VSS gf180mcu_fd_sc_mcu7t5v0__filltie
XFILLER_50_597 VDD VDD VSS VSS gf180mcu_fd_sc_mcu7t5v0__fill_1
XFILLER_77_417 VDD VDD VSS VSS gf180mcu_fd_sc_mcu7t5v0__fill_2
XFILLER_49_119 VDD VDD VSS VSS gf180mcu_fd_sc_mcu7t5v0__fillcap_16
XFILLER_38_33 VDD VDD VSS VSS gf180mcu_fd_sc_mcu7t5v0__fill_2
XFILLER_18_539 VDD VDD VSS VSS gf180mcu_fd_sc_mcu7t5v0__fillcap_16
XFILLER_73_623 VDD VDD VSS VSS gf180mcu_fd_sc_mcu7t5v0__fillcap_4
XFILLER_72_111 VDD VDD VSS VSS gf180mcu_fd_sc_mcu7t5v0__fill_1
XFILLER_72_133 VDD VDD VSS VSS gf180mcu_fd_sc_mcu7t5v0__fill_1
XFILLER_72_177 VDD VDD VSS VSS gf180mcu_fd_sc_mcu7t5v0__fillcap_16
XFILLER_72_166 VDD VDD VSS VSS gf180mcu_fd_sc_mcu7t5v0__fillcap_8
XFILLER_60_317 VDD VDD VSS VSS gf180mcu_fd_sc_mcu7t5v0__fillcap_64
XFILLER_70_53 VDD VDD VSS VSS gf180mcu_fd_sc_mcu7t5v0__fill_2
Xclkload18 _2172_/CLK clkload18/Z VDD VDD VSS VSS gf180mcu_fd_sc_mcu7t5v0__clkbuf_2
XPHY_EDGE_ROW_10_Left_109 VDD VSS gf180mcu_fd_sc_mcu7t5v0__endcap
X_1280_ _1280_/A1 _1281_/A1 _1281_/B _1280_/A4 _1284_/A2 VDD VDD VSS VSS gf180mcu_fd_sc_mcu7t5v0__nor4_1
XTAP_TAPCELL_ROW_8_292 VDD VSS gf180mcu_fd_sc_mcu7t5v0__filltie
XFILLER_95_72 VDD VDD VSS VSS gf180mcu_fd_sc_mcu7t5v0__fillcap_64
XFILLER_48_163 VDD VDD VSS VSS gf180mcu_fd_sc_mcu7t5v0__fillcap_4
XFILLER_24_509 VDD VDD VSS VSS gf180mcu_fd_sc_mcu7t5v0__fill_1
XFILLER_64_667 VDD VDD VSS VSS gf180mcu_fd_sc_mcu7t5v0__fillcap_16
XFILLER_63_133 VDD VDD VSS VSS gf180mcu_fd_sc_mcu7t5v0__fillcap_4
XTAP_TAPCELL_ROW_62_802 VDD VSS gf180mcu_fd_sc_mcu7t5v0__filltie
XFILLER_51_306 VDD VDD VSS VSS gf180mcu_fd_sc_mcu7t5v0__fill_2
XFILLER_32_542 VDD VDD VSS VSS gf180mcu_fd_sc_mcu7t5v0__fillcap_32
XTAP_TAPCELL_ROW_34_537 VDD VSS gf180mcu_fd_sc_mcu7t5v0__filltie
XFILLER_32_597 VDD VDD VSS VSS gf180mcu_fd_sc_mcu7t5v0__fillcap_16
XFILLER_81_2 VDD VDD VSS VSS gf180mcu_fd_sc_mcu7t5v0__fillcap_64
X_0995_ _1580_/A1 _1937_/Q _1936_/Q _0996_/C VDD VDD VSS VSS gf180mcu_fd_sc_mcu7t5v0__nand3_1
X_1616_ input8/Z _1989_/Q _1616_/S _1989_/D VDD VDD VSS VSS gf180mcu_fd_sc_mcu7t5v0__mux2_2
X_1547_ _1550_/B _1559_/A2 VDD VDD VSS VSS gf180mcu_fd_sc_mcu7t5v0__clkinv_1
X_1478_ _1478_/A1 _1577_/A1 _1458_/Z _1511_/C _1479_/A2 VDD VDD VSS VSS gf180mcu_fd_sc_mcu7t5v0__nand4_1
XFILLER_86_247 VDD VDD VSS VSS gf180mcu_fd_sc_mcu7t5v0__fillcap_32
XFILLER_27_336 VDD VDD VSS VSS gf180mcu_fd_sc_mcu7t5v0__fillcap_8
XFILLER_82_453 VDD VDD VSS VSS gf180mcu_fd_sc_mcu7t5v0__fill_2
XFILLER_82_431 VDD VDD VSS VSS gf180mcu_fd_sc_mcu7t5v0__fill_2
XFILLER_54_177 VDD VDD VSS VSS gf180mcu_fd_sc_mcu7t5v0__fillcap_16
XFILLER_10_247 VDD VDD VSS VSS gf180mcu_fd_sc_mcu7t5v0__fill_1
XFILLER_2_413 VDD VDD VSS VSS gf180mcu_fd_sc_mcu7t5v0__fillcap_8
XFILLER_40_89 VDD VDD VSS VSS gf180mcu_fd_sc_mcu7t5v0__fillcap_16
XFILLER_2_457 VDD VDD VSS VSS gf180mcu_fd_sc_mcu7t5v0__fillcap_64
XFILLER_77_214 VDD VDD VSS VSS gf180mcu_fd_sc_mcu7t5v0__fill_1
XFILLER_49_87 VDD VDD VSS VSS gf180mcu_fd_sc_mcu7t5v0__fillcap_32
XTAP_TAPCELL_ROW_5_262 VDD VSS gf180mcu_fd_sc_mcu7t5v0__filltie
XFILLER_77_269 VDD VDD VSS VSS gf180mcu_fd_sc_mcu7t5v0__fill_2
XFILLER_18_303 VDD VDD VSS VSS gf180mcu_fd_sc_mcu7t5v0__fill_1
XFILLER_18_325 VDD VDD VSS VSS gf180mcu_fd_sc_mcu7t5v0__fillcap_4
XTAP_TAPCELL_ROW_76_938 VDD VSS gf180mcu_fd_sc_mcu7t5v0__filltie
XFILLER_45_100 VDD VDD VSS VSS gf180mcu_fd_sc_mcu7t5v0__fill_2
XFILLER_18_347 VDD VDD VSS VSS gf180mcu_fd_sc_mcu7t5v0__fillcap_32
XTAP_TAPCELL_ROW_86_1034 VDD VSS gf180mcu_fd_sc_mcu7t5v0__filltie
XFILLER_73_442 VDD VDD VSS VSS gf180mcu_fd_sc_mcu7t5v0__fill_1
XFILLER_46_667 VDD VDD VSS VSS gf180mcu_fd_sc_mcu7t5v0__fill_2
XFILLER_33_306 VDD VDD VSS VSS gf180mcu_fd_sc_mcu7t5v0__fill_2
XFILLER_73_486 VDD VDD VSS VSS gf180mcu_fd_sc_mcu7t5v0__fillcap_4
XFILLER_61_626 VDD VDD VSS VSS gf180mcu_fd_sc_mcu7t5v0__fillcap_4
XFILLER_45_166 VDD VDD VSS VSS gf180mcu_fd_sc_mcu7t5v0__fillcap_32
XTAP_TAPCELL_ROW_31_507 VDD VSS gf180mcu_fd_sc_mcu7t5v0__filltie
XFILLER_14_597 VDD VDD VSS VSS gf180mcu_fd_sc_mcu7t5v0__fillcap_64
XTAP_TAPCELL_ROW_97_1130 VDD VSS gf180mcu_fd_sc_mcu7t5v0__filltie
X_1401_ _1401_/I _1401_/ZN VDD VDD VSS VSS gf180mcu_fd_sc_mcu7t5v0__clkinv_1
XFILLER_96_512 VDD VDD VSS VSS gf180mcu_fd_sc_mcu7t5v0__fillcap_8
X_1332_ _1335_/A1 _1328_/B _1332_/A3 _1332_/A4 _1332_/ZN VDD VDD VSS VSS gf180mcu_fd_sc_mcu7t5v0__nor4_1
XFILLER_68_247 VDD VDD VSS VSS gf180mcu_fd_sc_mcu7t5v0__fillcap_16
XFILLER_68_236 VDD VDD VSS VSS gf180mcu_fd_sc_mcu7t5v0__fillcap_8
XFILLER_68_225 VDD VDD VSS VSS gf180mcu_fd_sc_mcu7t5v0__fill_2
X_1263_ _2165_/Q _1260_/Z _1267_/A2 VDD VDD VSS VSS gf180mcu_fd_sc_mcu7t5v0__nand2_1
XFILLER_83_206 VDD VDD VSS VSS gf180mcu_fd_sc_mcu7t5v0__fillcap_4
Xinput5 cfg_addr_i[4] input5/Z VDD VDD VSS VSS gf180mcu_fd_sc_mcu7t5v0__dlyb_1
X_1194_ _1195_/A1 _1974_/Q _1195_/A3 _1195_/A4 _1194_/Z VDD VDD VSS VSS gf180mcu_fd_sc_mcu7t5v0__and4_1
XFILLER_24_317 VDD VDD VSS VSS gf180mcu_fd_sc_mcu7t5v0__fillcap_8
XFILLER_36_177 VDD VDD VSS VSS gf180mcu_fd_sc_mcu7t5v0__fillcap_8
XTAP_TAPCELL_ROW_47_662 VDD VSS gf180mcu_fd_sc_mcu7t5v0__filltie
XFILLER_36_199 VDD VDD VSS VSS gf180mcu_fd_sc_mcu7t5v0__fillcap_4
XTAP_TAPCELL_ROW_19_397 VDD VSS gf180mcu_fd_sc_mcu7t5v0__filltie
XFILLER_51_158 VDD VDD VSS VSS gf180mcu_fd_sc_mcu7t5v0__fill_1
X_0978_ _1332_/A3 input34/Z _1376_/A2 _0978_/A4 _2113_/D VDD VDD VSS VSS gf180mcu_fd_sc_mcu7t5v0__and4_1
XFILLER_10_37 VDD VDD VSS VSS gf180mcu_fd_sc_mcu7t5v0__fillcap_64
XFILLER_59_203 VDD VDD VSS VSS gf180mcu_fd_sc_mcu7t5v0__fillcap_4
XFILLER_59_258 VDD VDD VSS VSS gf180mcu_fd_sc_mcu7t5v0__fill_1
XFILLER_28_667 VDD VDD VSS VSS gf180mcu_fd_sc_mcu7t5v0__fill_2
XTAP_TAPCELL_ROW_73_908 VDD VSS gf180mcu_fd_sc_mcu7t5v0__filltie
XTAP_TAPCELL_ROW_2_232 VDD VSS gf180mcu_fd_sc_mcu7t5v0__filltie
XFILLER_70_401 VDD VDD VSS VSS gf180mcu_fd_sc_mcu7t5v0__fill_1
XFILLER_82_283 VDD VDD VSS VSS gf180mcu_fd_sc_mcu7t5v0__fill_1
XTAP_TAPCELL_ROW_81_985 VDD VSS gf180mcu_fd_sc_mcu7t5v0__filltie
XFILLER_70_489 VDD VDD VSS VSS gf180mcu_fd_sc_mcu7t5v0__fillcap_8
Xclkbuf_4_14_0_sys_clk_i clkbuf_0_sys_clk_i/Z clkbuf_4_14_0_sys_clk_i/Z VDD VDD VSS
+ VSS gf180mcu_fd_sc_mcu7t5v0__clkbuf_2
Xwire403 wire403/I cfg_rx_size_o[3] VDD VDD VSS VSS gf180mcu_fd_sc_mcu7t5v0__clkbuf_3
Xwire414 wire414/I cfg_rx_continuous_o VDD VDD VSS VSS gf180mcu_fd_sc_mcu7t5v0__clkbuf_3
XFILLER_51_88 VDD VDD VSS VSS gf180mcu_fd_sc_mcu7t5v0__fillcap_4
XFILLER_51_66 VDD VDD VSS VSS gf180mcu_fd_sc_mcu7t5v0__fillcap_4
XTAP_TAPCELL_ROW_92_1082 VDD VSS gf180mcu_fd_sc_mcu7t5v0__filltie
Xclkbuf_5_0__f_periph_clk_i clkbuf_4_0_0_periph_clk_i/Z _2125_/CLK VDD VDD VSS VSS
+ gf180mcu_fd_sc_mcu7t5v0__clkbuf_16
XFILLER_78_567 VDD VDD VSS VSS gf180mcu_fd_sc_mcu7t5v0__fillcap_4
XFILLER_19_656 VDD VDD VSS VSS gf180mcu_fd_sc_mcu7t5v0__fill_1
XFILLER_93_559 VDD VDD VSS VSS gf180mcu_fd_sc_mcu7t5v0__fill_1
XFILLER_46_420 VDD VDD VSS VSS gf180mcu_fd_sc_mcu7t5v0__fill_1
XFILLER_18_177 VDD VDD VSS VSS gf180mcu_fd_sc_mcu7t5v0__fillcap_16
XFILLER_18_199 VDD VDD VSS VSS gf180mcu_fd_sc_mcu7t5v0__fill_1
XTAP_TAPCELL_ROW_44_632 VDD VSS gf180mcu_fd_sc_mcu7t5v0__filltie
XFILLER_14_383 VDD VDD VSS VSS gf180mcu_fd_sc_mcu7t5v0__fill_2
X_1950_ _1950_/D _1957_/RN _1952_/CLK _1950_/Q VDD VDD VSS VSS gf180mcu_fd_sc_mcu7t5v0__dffrnq_1
XTAP_TAPCELL_ROW_16_367 VDD VSS gf180mcu_fd_sc_mcu7t5v0__filltie
X_1881_ _1881_/D _2155_/RN _2154_/CLK _1881_/Q VDD VDD VSS VSS gf180mcu_fd_sc_mcu7t5v0__dffrnq_1
X_0901_ _1956_/Q _1578_/A1 VDD VDD VSS VSS gf180mcu_fd_sc_mcu7t5v0__clkinv_1
XFILLER_6_582 VDD VDD VSS VSS gf180mcu_fd_sc_mcu7t5v0__fillcap_8
XFILLER_69_512 VDD VDD VSS VSS gf180mcu_fd_sc_mcu7t5v0__fill_2
X_1315_ _2071_/Q _1829_/A3 _1314_/Z _2082_/Q _2070_/Q _1316_/B VDD VDD VSS VSS gf180mcu_fd_sc_mcu7t5v0__aoi221_1
XFILLER_69_589 VDD VDD VSS VSS gf180mcu_fd_sc_mcu7t5v0__fillcap_4
X_1246_ _2144_/Q _2145_/Q _1246_/A3 _1246_/Z VDD VDD VSS VSS gf180mcu_fd_sc_mcu7t5v0__and3_1
X_1177_ _1332_/A4 _1328_/B _1332_/A3 _1177_/ZN VDD VDD VSS VSS gf180mcu_fd_sc_mcu7t5v0__nor3_1
XFILLER_71_209 VDD VDD VSS VSS gf180mcu_fd_sc_mcu7t5v0__fill_1
XFILLER_52_467 VDD VDD VSS VSS gf180mcu_fd_sc_mcu7t5v0__fillcap_32
XFILLER_21_36 VDD VDD VSS VSS gf180mcu_fd_sc_mcu7t5v0__fillcap_32
Xoutput161 _1997_/Q wire399/I VDD VDD VSS VSS gf180mcu_fd_sc_mcu7t5v0__buf_1
Xoutput150 _2001_/Q wire410/I VDD VDD VSS VSS gf180mcu_fd_sc_mcu7t5v0__buf_1
Xoutput194 _2028_/Q wire366/I VDD VDD VSS VSS gf180mcu_fd_sc_mcu7t5v0__buf_1
Xoutput183 _2032_/Q wire377/I VDD VDD VSS VSS gf180mcu_fd_sc_mcu7t5v0__buf_1
Xoutput172 _1984_/Q wire388/I VDD VDD VSS VSS gf180mcu_fd_sc_mcu7t5v0__buf_1
XFILLER_75_559 VDD VDD VSS VSS gf180mcu_fd_sc_mcu7t5v0__fill_1
XFILLER_28_453 VDD VDD VSS VSS gf180mcu_fd_sc_mcu7t5v0__fill_2
XTAP_TAPCELL_ROW_58_768 VDD VSS gf180mcu_fd_sc_mcu7t5v0__filltie
XFILLER_62_209 VDD VDD VSS VSS gf180mcu_fd_sc_mcu7t5v0__fillcap_16
XTAP_TAPCELL_ROW_83_1004 VDD VSS gf180mcu_fd_sc_mcu7t5v0__filltie
XTAP_TAPCELL_ROW_41_602 VDD VSS gf180mcu_fd_sc_mcu7t5v0__filltie
XFILLER_62_32 VDD VDD VSS VSS gf180mcu_fd_sc_mcu7t5v0__fill_2
XFILLER_43_489 VDD VDD VSS VSS gf180mcu_fd_sc_mcu7t5v0__fill_1
XFILLER_23_191 VDD VDD VSS VSS gf180mcu_fd_sc_mcu7t5v0__fillcap_16
XTAP_TAPCELL_ROW_13_337 VDD VSS gf180mcu_fd_sc_mcu7t5v0__filltie
XFILLER_70_297 VDD VDD VSS VSS gf180mcu_fd_sc_mcu7t5v0__fillcap_4
XFILLER_11_375 VDD VDD VSS VSS gf180mcu_fd_sc_mcu7t5v0__fillcap_16
Xclkbuf_5_15__f_periph_clk_i clkbuf_4_7_0_periph_clk_i/Z _2058_/CLK VDD VDD VSS VSS
+ gf180mcu_fd_sc_mcu7t5v0__clkbuf_16
Xwire244 wire244/I cfg_data_o[14] VDD VDD VSS VSS gf180mcu_fd_sc_mcu7t5v0__clkbuf_3
Xwire266 wire266/I _1645_/S VDD VDD VSS VSS gf180mcu_fd_sc_mcu7t5v0__dlyb_1
Xwire233 wire233/I _1450_/S VDD VDD VSS VSS gf180mcu_fd_sc_mcu7t5v0__dlyb_1
Xwire288 wire288/I data_rx_o[5] VDD VDD VSS VSS gf180mcu_fd_sc_mcu7t5v0__clkbuf_3
Xwire299 wire299/I cfg_data_o[26] VDD VDD VSS VSS gf180mcu_fd_sc_mcu7t5v0__clkbuf_3
XFILLER_98_618 VDD VDD VSS VSS gf180mcu_fd_sc_mcu7t5v0__fillcap_16
XFILLER_30_8 VDD VDD VSS VSS gf180mcu_fd_sc_mcu7t5v0__fillcap_4
XFILLER_3_596 VDD VDD VSS VSS gf180mcu_fd_sc_mcu7t5v0__fillcap_32
X_1100_ _2093_/Q _2169_/Q _1100_/Z VDD VDD VSS VSS gf180mcu_fd_sc_mcu7t5v0__or2_1
X_2080_ _2080_/D _2081_/RN _2142_/CLK _2080_/Q VDD VDD VSS VSS gf180mcu_fd_sc_mcu7t5v0__dffrnq_1
XFILLER_38_239 VDD VDD VSS VSS gf180mcu_fd_sc_mcu7t5v0__fillcap_4
X_1031_ _2087_/Q _2132_/Q _1038_/A4 VDD VDD VSS VSS gf180mcu_fd_sc_mcu7t5v0__xnor2_1
XFILLER_46_261 VDD VDD VSS VSS gf180mcu_fd_sc_mcu7t5v0__fillcap_8
Xclkbuf_4_3_0_periph_clk_i clkbuf_0_periph_clk_i/Z clkbuf_4_3_0_periph_clk_i/Z VDD
+ VDD VSS VSS gf180mcu_fd_sc_mcu7t5v0__clkbuf_2
XTAP_TAPCELL_ROW_29_492 VDD VSS gf180mcu_fd_sc_mcu7t5v0__filltie
XFILLER_61_242 VDD VDD VSS VSS gf180mcu_fd_sc_mcu7t5v0__fillcap_16
XFILLER_34_489 VDD VDD VSS VSS gf180mcu_fd_sc_mcu7t5v0__fillcap_16
X_1933_ _1933_/D _2082_/RN _2082_/CLK _1933_/Q VDD VDD VSS VSS gf180mcu_fd_sc_mcu7t5v0__dffsnq_1
X_1864_ _1864_/D _2156_/RN _2155_/CLK _1864_/Q VDD VDD VSS VSS gf180mcu_fd_sc_mcu7t5v0__dffrnq_1
Xinput30 cfg_data_i[31] input30/Z VDD VDD VSS VSS gf180mcu_fd_sc_mcu7t5v0__dlyb_1
X_1795_ _1826_/A1 _1313_/Z _2076_/Q _1811_/A4 _1801_/C VDD VDD VSS VSS gf180mcu_fd_sc_mcu7t5v0__nand4_1
Xinput41 cfg_rx_bytes_left_i[11] input41/Z VDD VDD VSS VSS gf180mcu_fd_sc_mcu7t5v0__dlyb_1
Xinput52 cfg_rx_bytes_left_i[7] input52/Z VDD VDD VSS VSS gf180mcu_fd_sc_mcu7t5v0__dlyb_1
Xinput63 cfg_rx_curr_addr_i[6] input63/Z VDD VDD VSS VSS gf180mcu_fd_sc_mcu7t5v0__dlyb_1
Xmax_cap544 _1627_/S _1631_/S VDD VDD VSS VSS gf180mcu_fd_sc_mcu7t5v0__buf_2
Xmax_cap533 _1416_/S _1421_/S VDD VDD VSS VSS gf180mcu_fd_sc_mcu7t5v0__clkbuf_2
Xinput96 cfg_tx_curr_addr_i[9] input96/Z VDD VDD VSS VSS gf180mcu_fd_sc_mcu7t5v0__dlyb_1
Xinput85 cfg_tx_curr_addr_i[0] input85/Z VDD VDD VSS VSS gf180mcu_fd_sc_mcu7t5v0__dlyb_1
Xinput74 cfg_tx_bytes_left_i[14] input74/Z VDD VDD VSS VSS gf180mcu_fd_sc_mcu7t5v0__dlyb_1
Xmax_cap555 _2036_/RN _2123_/RN VDD VDD VSS VSS gf180mcu_fd_sc_mcu7t5v0__buf_2
XFILLER_97_640 VDD VDD VSS VSS gf180mcu_fd_sc_mcu7t5v0__fillcap_4
XFILLER_29_206 VDD VDD VSS VSS gf180mcu_fd_sc_mcu7t5v0__fillcap_4
X_1229_ _2138_/Q _2139_/Q _2140_/Q _1218_/Z _1229_/Z VDD VDD VSS VSS gf180mcu_fd_sc_mcu7t5v0__and4_1
XFILLER_72_518 VDD VDD VSS VSS gf180mcu_fd_sc_mcu7t5v0__fill_1
XTAP_TAPCELL_ROW_55_738 VDD VSS gf180mcu_fd_sc_mcu7t5v0__filltie
XFILLER_80_562 VDD VDD VSS VSS gf180mcu_fd_sc_mcu7t5v0__fillcap_4
XFILLER_52_242 VDD VDD VSS VSS gf180mcu_fd_sc_mcu7t5v0__fill_2
XFILLER_13_629 VDD VDD VSS VSS gf180mcu_fd_sc_mcu7t5v0__fill_1
XFILLER_25_478 VDD VDD VSS VSS gf180mcu_fd_sc_mcu7t5v0__fill_2
XFILLER_40_448 VDD VDD VSS VSS gf180mcu_fd_sc_mcu7t5v0__fill_2
XTAP_TAPCELL_ROW_10_307 VDD VSS gf180mcu_fd_sc_mcu7t5v0__filltie
XFILLER_20_194 VDD VDD VSS VSS gf180mcu_fd_sc_mcu7t5v0__fillcap_32
XFILLER_79_139 VDD VDD VSS VSS gf180mcu_fd_sc_mcu7t5v0__fill_1
XFILLER_57_10 VDD VDD VSS VSS gf180mcu_fd_sc_mcu7t5v0__fillcap_4
XFILLER_75_345 VDD VDD VSS VSS gf180mcu_fd_sc_mcu7t5v0__fillcap_4
XFILLER_35_209 VDD VDD VSS VSS gf180mcu_fd_sc_mcu7t5v0__fill_1
XFILLER_28_294 VDD VDD VSS VSS gf180mcu_fd_sc_mcu7t5v0__fillcap_16
XFILLER_73_53 VDD VDD VSS VSS gf180mcu_fd_sc_mcu7t5v0__fill_2
XTAP_TAPCELL_ROW_26_462 VDD VSS gf180mcu_fd_sc_mcu7t5v0__filltie
XFILLER_71_562 VDD VDD VSS VSS gf180mcu_fd_sc_mcu7t5v0__fillcap_16
X_1580_ _1580_/A1 _1580_/A2 _1580_/A3 _1956_/Q _1582_/A2 VDD VDD VSS VSS gf180mcu_fd_sc_mcu7t5v0__nand4_1
X_2132_ _2132_/D _2136_/RN _2134_/CLK _2132_/Q VDD VDD VSS VSS gf180mcu_fd_sc_mcu7t5v0__dffrnq_1
XFILLER_78_172 VDD VDD VSS VSS gf180mcu_fd_sc_mcu7t5v0__fill_2
XFILLER_93_142 VDD VDD VSS VSS gf180mcu_fd_sc_mcu7t5v0__fillcap_64
XFILLER_54_518 VDD VDD VSS VSS gf180mcu_fd_sc_mcu7t5v0__fillcap_4
X_2063_ _2063_/D _2161_/RN _2063_/CLK _2063_/Q VDD VDD VSS VSS gf180mcu_fd_sc_mcu7t5v0__dffsnq_1
X_1014_ _1813_/A1 _1014_/A2 _1815_/C VDD VDD VSS VSS gf180mcu_fd_sc_mcu7t5v0__nand2_1
XTAP_TAPCELL_ROW_52_708 VDD VSS gf180mcu_fd_sc_mcu7t5v0__filltie
XFILLER_81_348 VDD VDD VSS VSS gf180mcu_fd_sc_mcu7t5v0__fill_2
XFILLER_34_275 VDD VDD VSS VSS gf180mcu_fd_sc_mcu7t5v0__fill_2
XFILLER_62_562 VDD VDD VSS VSS gf180mcu_fd_sc_mcu7t5v0__fillcap_32
X_1916_ _1916_/D _1951_/RN _1921_/CLK _1916_/Q VDD VDD VSS VSS gf180mcu_fd_sc_mcu7t5v0__dffrnq_1
XTAP_TAPCELL_ROW_60_785 VDD VSS gf180mcu_fd_sc_mcu7t5v0__filltie
X_1847_ _1969_/Q _2094_/Q _1847_/S _2094_/D VDD VDD VSS VSS gf180mcu_fd_sc_mcu7t5v0__mux2_2
X_1778_ _2073_/Q _1810_/A2 _1785_/B VDD VDD VSS VSS gf180mcu_fd_sc_mcu7t5v0__nand2_1
Xmax_cap341 _1311_/S0 _1312_/S0 VDD VDD VSS VSS gf180mcu_fd_sc_mcu7t5v0__buf_2
Xmax_cap330 _1289_/A2 _1278_/A3 VDD VDD VSS VSS gf180mcu_fd_sc_mcu7t5v0__dlyb_1
XFILLER_85_632 VDD VDD VSS VSS gf180mcu_fd_sc_mcu7t5v0__fillcap_32
XTAP_TAPCELL_ROW_68_863 VDD VSS gf180mcu_fd_sc_mcu7t5v0__filltie
XFILLER_27_68 VDD VDD VSS VSS gf180mcu_fd_sc_mcu7t5v0__fill_2
XFILLER_25_264 VDD VDD VSS VSS gf180mcu_fd_sc_mcu7t5v0__fill_1
XFILLER_80_370 VDD VDD VSS VSS gf180mcu_fd_sc_mcu7t5v0__fillcap_8
XFILLER_53_562 VDD VDD VSS VSS gf180mcu_fd_sc_mcu7t5v0__fillcap_8
XFILLER_43_45 VDD VDD VSS VSS gf180mcu_fd_sc_mcu7t5v0__fill_2
XTAP_TAPCELL_ROW_23_432 VDD VSS gf180mcu_fd_sc_mcu7t5v0__filltie
XFILLER_43_67 VDD VDD VSS VSS gf180mcu_fd_sc_mcu7t5v0__fill_2
XFILLER_21_492 VDD VDD VSS VSS gf180mcu_fd_sc_mcu7t5v0__fillcap_8
XFILLER_76_610 VDD VDD VSS VSS gf180mcu_fd_sc_mcu7t5v0__fill_1
XFILLER_48_312 VDD VDD VSS VSS gf180mcu_fd_sc_mcu7t5v0__fill_2
XTAP_TAPCELL_ROW_89_1054 VDD VSS gf180mcu_fd_sc_mcu7t5v0__filltie
XFILLER_75_142 VDD VDD VSS VSS gf180mcu_fd_sc_mcu7t5v0__fillcap_32
XFILLER_48_367 VDD VDD VSS VSS gf180mcu_fd_sc_mcu7t5v0__fillcap_8
XFILLER_90_101 VDD VDD VSS VSS gf180mcu_fd_sc_mcu7t5v0__fillcap_4
XFILLER_31_212 VDD VDD VSS VSS gf180mcu_fd_sc_mcu7t5v0__fillcap_64
XFILLER_12_481 VDD VDD VSS VSS gf180mcu_fd_sc_mcu7t5v0__fill_1
X_1701_ _1703_/C _1702_/A1 _2105_/Q _1702_/B VDD VDD VSS VSS gf180mcu_fd_sc_mcu7t5v0__oai21_1
XFILLER_8_452 VDD VDD VSS VSS gf180mcu_fd_sc_mcu7t5v0__fill_2
X_1632_ _2004_/Q input11/Z _1633_/S _2004_/D VDD VDD VSS VSS gf180mcu_fd_sc_mcu7t5v0__mux2_2
X_1563_ _1942_/Q _1571_/I0 _1563_/S _1942_/D VDD VDD VSS VSS gf180mcu_fd_sc_mcu7t5v0__mux2_2
X_1494_ _1497_/A1 _1523_/A2 _1494_/B _1909_/D VDD VDD VSS VSS gf180mcu_fd_sc_mcu7t5v0__oai21_1
XFILLER_79_492 VDD VDD VSS VSS gf180mcu_fd_sc_mcu7t5v0__fillcap_4
XFILLER_67_632 VDD VDD VSS VSS gf180mcu_fd_sc_mcu7t5v0__fillcap_32
XFILLER_66_153 VDD VDD VSS VSS gf180mcu_fd_sc_mcu7t5v0__fillcap_4
XFILLER_39_356 VDD VDD VSS VSS gf180mcu_fd_sc_mcu7t5v0__fill_1
X_2115_ _2115_/D _2115_/RN clkload1/I _2115_/Q VDD VDD VSS VSS gf180mcu_fd_sc_mcu7t5v0__dffrnq_1
XTAP_TAPCELL_ROW_65_833 VDD VSS gf180mcu_fd_sc_mcu7t5v0__filltie
XFILLER_39_389 VDD VDD VSS VSS gf180mcu_fd_sc_mcu7t5v0__fillcap_4
X_2046_ _2046_/D _2188_/RN clkload3/I _2046_/Q VDD VDD VSS VSS gf180mcu_fd_sc_mcu7t5v0__dffrnq_1
XFILLER_81_123 VDD VDD VSS VSS gf180mcu_fd_sc_mcu7t5v0__fillcap_16
XFILLER_22_201 VDD VDD VSS VSS gf180mcu_fd_sc_mcu7t5v0__fill_1
XTAP_TAPCELL_ROW_37_568 VDD VSS gf180mcu_fd_sc_mcu7t5v0__filltie
XTAP_TAPCELL_ROW_20_402 VDD VSS gf180mcu_fd_sc_mcu7t5v0__filltie
XFILLER_89_212 VDD VDD VSS VSS gf180mcu_fd_sc_mcu7t5v0__fillcap_64
XFILLER_38_45 VDD VDD VSS VSS gf180mcu_fd_sc_mcu7t5v0__fill_2
XFILLER_73_602 VDD VDD VSS VSS gf180mcu_fd_sc_mcu7t5v0__fill_1
XFILLER_57_142 VDD VDD VSS VSS gf180mcu_fd_sc_mcu7t5v0__fillcap_8
XFILLER_85_473 VDD VDD VSS VSS gf180mcu_fd_sc_mcu7t5v0__fill_2
XFILLER_72_123 VDD VDD VSS VSS gf180mcu_fd_sc_mcu7t5v0__fillcap_8
XFILLER_54_33 VDD VDD VSS VSS gf180mcu_fd_sc_mcu7t5v0__fill_2
XFILLER_13_212 VDD VDD VSS VSS gf180mcu_fd_sc_mcu7t5v0__fill_1
XFILLER_13_234 VDD VDD VSS VSS gf180mcu_fd_sc_mcu7t5v0__fill_2
XFILLER_53_370 VDD VDD VSS VSS gf180mcu_fd_sc_mcu7t5v0__fillcap_32
XFILLER_41_554 VDD VDD VSS VSS gf180mcu_fd_sc_mcu7t5v0__fillcap_4
XFILLER_13_278 VDD VDD VSS VSS gf180mcu_fd_sc_mcu7t5v0__fill_2
XFILLER_9_227 VDD VDD VSS VSS gf180mcu_fd_sc_mcu7t5v0__fill_2
Xclkload19 _2170_/CLK clkload19/Z VDD VDD VSS VSS gf180mcu_fd_sc_mcu7t5v0__clkbuf_2
XFILLER_5_422 VDD VDD VSS VSS gf180mcu_fd_sc_mcu7t5v0__fillcap_4
XFILLER_79_96 VDD VDD VSS VSS gf180mcu_fd_sc_mcu7t5v0__fill_2
XTAP_TAPCELL_ROW_8_293 VDD VSS gf180mcu_fd_sc_mcu7t5v0__filltie
XFILLER_49_632 VDD VDD VSS VSS gf180mcu_fd_sc_mcu7t5v0__fillcap_8
XFILLER_49_610 VDD VDD VSS VSS gf180mcu_fd_sc_mcu7t5v0__fillcap_4
XFILLER_17_562 VDD VDD VSS VSS gf180mcu_fd_sc_mcu7t5v0__fillcap_16
XTAP_TAPCELL_ROW_62_803 VDD VSS gf180mcu_fd_sc_mcu7t5v0__filltie
XTAP_TAPCELL_ROW_34_538 VDD VSS gf180mcu_fd_sc_mcu7t5v0__filltie
XTAP_TAPCELL_ROW_70_880 VDD VSS gf180mcu_fd_sc_mcu7t5v0__filltie
X_0994_ _1956_/Q _1957_/Q _0994_/Z VDD VDD VSS VSS gf180mcu_fd_sc_mcu7t5v0__xor2_1
X_1615_ input7/Z _1988_/Q _1616_/S _1988_/D VDD VDD VSS VSS gf180mcu_fd_sc_mcu7t5v0__mux2_2
X_1546_ _1557_/A1 _1580_/A3 _1550_/B VDD VDD VSS VSS gf180mcu_fd_sc_mcu7t5v0__nand2_1
X_1477_ _1474_/B _1474_/C _1477_/B _1510_/A2 VDD VDD VSS VSS gf180mcu_fd_sc_mcu7t5v0__aoi21_1
XFILLER_27_348 VDD VDD VSS VSS gf180mcu_fd_sc_mcu7t5v0__fill_2
XFILLER_70_605 VDD VDD VSS VSS gf180mcu_fd_sc_mcu7t5v0__fillcap_4
X_2029_ _2029_/D _2031_/RN _2031_/CLK _2029_/Q VDD VDD VSS VSS gf180mcu_fd_sc_mcu7t5v0__dffrnq_1
XFILLER_23_554 VDD VDD VSS VSS gf180mcu_fd_sc_mcu7t5v0__fillcap_4
Xclkbuf_4_13_0_sys_clk_i clkbuf_0_sys_clk_i/Z clkbuf_4_13_0_sys_clk_i/Z VDD VDD VSS
+ VSS gf180mcu_fd_sc_mcu7t5v0__clkbuf_2
XTAP_TAPCELL_ROW_5_263 VDD VSS gf180mcu_fd_sc_mcu7t5v0__filltie
XTAP_TAPCELL_ROW_76_939 VDD VSS gf180mcu_fd_sc_mcu7t5v0__filltie
XFILLER_46_613 VDD VDD VSS VSS gf180mcu_fd_sc_mcu7t5v0__fillcap_8
XFILLER_65_43 VDD VDD VSS VSS gf180mcu_fd_sc_mcu7t5v0__fillcap_16
XFILLER_65_87 VDD VDD VSS VSS gf180mcu_fd_sc_mcu7t5v0__fill_1
XFILLER_60_115 VDD VDD VSS VSS gf180mcu_fd_sc_mcu7t5v0__fill_2
XTAP_TAPCELL_ROW_31_508 VDD VSS gf180mcu_fd_sc_mcu7t5v0__filltie
XTAP_TAPCELL_ROW_97_1131 VDD VSS gf180mcu_fd_sc_mcu7t5v0__filltie
X_1400_ input73/Z _1404_/A2 _1404_/B1 input43/Z _1401_/I VDD VDD VSS VSS gf180mcu_fd_sc_mcu7t5v0__aoi22_1
X_1331_ _1353_/A1 _1353_/A2 _1354_/A3 _2111_/Q _1340_/A1 VDD VDD VSS VSS gf180mcu_fd_sc_mcu7t5v0__nand4_1
XFILLER_96_524 VDD VDD VSS VSS gf180mcu_fd_sc_mcu7t5v0__fill_1
X_1262_ _1294_/A1 _1262_/A2 _1270_/A4 _1294_/A4 _2164_/D VDD VDD VSS VSS gf180mcu_fd_sc_mcu7t5v0__and4_1
Xinput6 cfg_data_i[0] input6/Z VDD VDD VSS VSS gf180mcu_fd_sc_mcu7t5v0__dlyb_1
XFILLER_49_473 VDD VDD VSS VSS gf180mcu_fd_sc_mcu7t5v0__fillcap_16
XFILLER_36_123 VDD VDD VSS VSS gf180mcu_fd_sc_mcu7t5v0__fillcap_8
X_1193_ _1195_/A1 _1973_/Q _1195_/A3 _1195_/A4 _1193_/Z VDD VDD VSS VSS gf180mcu_fd_sc_mcu7t5v0__and4_1
XTAP_TAPCELL_ROW_47_663 VDD VSS gf180mcu_fd_sc_mcu7t5v0__filltie
XFILLER_64_454 VDD VDD VSS VSS gf180mcu_fd_sc_mcu7t5v0__fill_1
XFILLER_36_189 VDD VDD VSS VSS gf180mcu_fd_sc_mcu7t5v0__fill_2
XFILLER_17_392 VDD VDD VSS VSS gf180mcu_fd_sc_mcu7t5v0__fill_2
Xclkbuf_5_10__f_sys_clk_i clkbuf_4_5_0_sys_clk_i/Z _2152_/CLK VDD VDD VSS VSS gf180mcu_fd_sc_mcu7t5v0__clkbuf_16
XFILLER_32_384 VDD VDD VSS VSS gf180mcu_fd_sc_mcu7t5v0__fill_1
XFILLER_60_693 VDD VDD VSS VSS gf180mcu_fd_sc_mcu7t5v0__fill_1
X_0977_ input32/Z _1332_/A3 _1376_/A2 _0978_/A4 _2114_/D VDD VDD VSS VSS gf180mcu_fd_sc_mcu7t5v0__and4_1
X_1529_ _2123_/D _2122_/D _1531_/S _1929_/D VDD VDD VSS VSS gf180mcu_fd_sc_mcu7t5v0__mux2_2
XFILLER_87_579 VDD VDD VSS VSS gf180mcu_fd_sc_mcu7t5v0__fillcap_8
XFILLER_59_248 VDD VDD VSS VSS gf180mcu_fd_sc_mcu7t5v0__fillcap_8
XFILLER_19_69 VDD VDD VSS VSS gf180mcu_fd_sc_mcu7t5v0__fill_1
XTAP_TAPCELL_ROW_73_909 VDD VSS gf180mcu_fd_sc_mcu7t5v0__filltie
XTAP_TAPCELL_ROW_2_233 VDD VSS gf180mcu_fd_sc_mcu7t5v0__filltie
Xclkbuf_5_23__f_periph_clk_i clkbuf_4_11_0_periph_clk_i/Z _2130_/CLK VDD VDD VSS VSS
+ gf180mcu_fd_sc_mcu7t5v0__clkbuf_16
XFILLER_82_240 VDD VDD VSS VSS gf180mcu_fd_sc_mcu7t5v0__fillcap_4
XFILLER_42_104 VDD VDD VSS VSS gf180mcu_fd_sc_mcu7t5v0__fill_1
XFILLER_70_457 VDD VDD VSS VSS gf180mcu_fd_sc_mcu7t5v0__fillcap_8
XFILLER_70_446 VDD VDD VSS VSS gf180mcu_fd_sc_mcu7t5v0__fillcap_8
XTAP_TAPCELL_ROW_81_986 VDD VSS gf180mcu_fd_sc_mcu7t5v0__filltie
Xwire404 wire404/I cfg_rx_size_o[2] VDD VDD VSS VSS gf180mcu_fd_sc_mcu7t5v0__clkbuf_3
Xwire415 wire415/I cfg_rx_clr_o VDD VDD VSS VSS gf180mcu_fd_sc_mcu7t5v0__clkbuf_3
XPHY_EDGE_ROW_14_Right_14 VDD VSS gf180mcu_fd_sc_mcu7t5v0__endcap
XFILLER_11_579 VDD VDD VSS VSS gf180mcu_fd_sc_mcu7t5v0__fillcap_8
XFILLER_4_2 VDD VDD VSS VSS gf180mcu_fd_sc_mcu7t5v0__fillcap_32
XTAP_TAPCELL_ROW_92_1083 VDD VSS gf180mcu_fd_sc_mcu7t5v0__filltie
XPHY_EDGE_ROW_23_Right_23 VDD VSS gf180mcu_fd_sc_mcu7t5v0__endcap
XFILLER_78_524 VDD VDD VSS VSS gf180mcu_fd_sc_mcu7t5v0__fill_1
XFILLER_19_613 VDD VDD VSS VSS gf180mcu_fd_sc_mcu7t5v0__fill_1
XFILLER_76_53 VDD VDD VSS VSS gf180mcu_fd_sc_mcu7t5v0__fillcap_8
XFILLER_65_218 VDD VDD VSS VSS gf180mcu_fd_sc_mcu7t5v0__fill_1
XFILLER_18_101 VDD VDD VSS VSS gf180mcu_fd_sc_mcu7t5v0__fillcap_4
XFILLER_93_549 VDD VDD VSS VSS gf180mcu_fd_sc_mcu7t5v0__fillcap_8
XTAP_TAPCELL_ROW_44_633 VDD VSS gf180mcu_fd_sc_mcu7t5v0__filltie
XPHY_EDGE_ROW_32_Right_32 VDD VSS gf180mcu_fd_sc_mcu7t5v0__endcap
Xclkbuf_4_11_0_periph_clk_i clkbuf_0_periph_clk_i/Z clkbuf_4_11_0_periph_clk_i/Z VDD
+ VDD VSS VSS gf180mcu_fd_sc_mcu7t5v0__clkbuf_2
XTAP_TAPCELL_ROW_16_368 VDD VSS gf180mcu_fd_sc_mcu7t5v0__filltie
X_1880_ _1880_/D _2155_/RN _2155_/CLK _1880_/Q VDD VDD VSS VSS gf180mcu_fd_sc_mcu7t5v0__dffrnq_1
XFILLER_6_594 VDD VDD VSS VSS gf180mcu_fd_sc_mcu7t5v0__fill_1
XPHY_EDGE_ROW_41_Right_41 VDD VSS gf180mcu_fd_sc_mcu7t5v0__endcap
XFILLER_69_524 VDD VDD VSS VSS gf180mcu_fd_sc_mcu7t5v0__fillcap_16
X_1314_ _2068_/Q _2069_/Q _1314_/Z VDD VDD VSS VSS gf180mcu_fd_sc_mcu7t5v0__and2_1
XFILLER_84_516 VDD VDD VSS VSS gf180mcu_fd_sc_mcu7t5v0__fillcap_8
X_1245_ _2144_/Q _1246_/A3 _2145_/Q _1247_/A2 VDD VDD VSS VSS gf180mcu_fd_sc_mcu7t5v0__aoi21_1
X_1176_ _1319_/B _1319_/C input1/Z _1332_/A4 VDD VDD VSS VSS gf180mcu_fd_sc_mcu7t5v0__nand3_1
XFILLER_24_104 VDD VDD VSS VSS gf180mcu_fd_sc_mcu7t5v0__fill_1
XPHY_EDGE_ROW_50_Right_50 VDD VSS gf180mcu_fd_sc_mcu7t5v0__endcap
XFILLER_64_273 VDD VDD VSS VSS gf180mcu_fd_sc_mcu7t5v0__fill_1
XFILLER_52_435 VDD VDD VSS VSS gf180mcu_fd_sc_mcu7t5v0__fillcap_8
XFILLER_52_457 VDD VDD VSS VSS gf180mcu_fd_sc_mcu7t5v0__fillcap_4
XFILLER_20_321 VDD VDD VSS VSS gf180mcu_fd_sc_mcu7t5v0__fill_2
XFILLER_20_387 VDD VDD VSS VSS gf180mcu_fd_sc_mcu7t5v0__fill_2
Xoutput151 _2002_/Q wire409/I VDD VDD VSS VSS gf180mcu_fd_sc_mcu7t5v0__buf_1
Xoutput140 _1379_/ZN wire224/I VDD VDD VSS VSS gf180mcu_fd_sc_mcu7t5v0__buf_1
Xoutput195 _2007_/Q wire365/I VDD VDD VSS VSS gf180mcu_fd_sc_mcu7t5v0__buf_1
Xoutput184 _2033_/Q wire376/I VDD VDD VSS VSS gf180mcu_fd_sc_mcu7t5v0__buf_1
Xoutput173 _1985_/Q wire387/I VDD VDD VSS VSS gf180mcu_fd_sc_mcu7t5v0__buf_1
Xoutput162 _1998_/Q wire398/I VDD VDD VSS VSS gf180mcu_fd_sc_mcu7t5v0__buf_1
XFILLER_28_421 VDD VDD VSS VSS gf180mcu_fd_sc_mcu7t5v0__fillcap_32
XFILLER_75_549 VDD VDD VSS VSS gf180mcu_fd_sc_mcu7t5v0__fillcap_8
XFILLER_46_34 VDD VDD VSS VSS gf180mcu_fd_sc_mcu7t5v0__fill_1
XTAP_TAPCELL_ROW_83_1005 VDD VSS gf180mcu_fd_sc_mcu7t5v0__filltie
XFILLER_70_243 VDD VDD VSS VSS gf180mcu_fd_sc_mcu7t5v0__fill_2
XTAP_TAPCELL_ROW_41_603 VDD VSS gf180mcu_fd_sc_mcu7t5v0__filltie
XTAP_TAPCELL_ROW_13_338 VDD VSS gf180mcu_fd_sc_mcu7t5v0__filltie
Xwire223 wire223/I data_rx_valid_o VDD VDD VSS VSS gf180mcu_fd_sc_mcu7t5v0__clkbuf_3
Xwire245 wire245/I cfg_data_o[13] VDD VDD VSS VSS gf180mcu_fd_sc_mcu7t5v0__clkbuf_3
Xwire289 wire289/I data_rx_o[4] VDD VDD VSS VSS gf180mcu_fd_sc_mcu7t5v0__clkbuf_3
XTAP_TAPCELL_ROW_94_1101 VDD VSS gf180mcu_fd_sc_mcu7t5v0__filltie
XFILLER_3_531 VDD VDD VSS VSS gf180mcu_fd_sc_mcu7t5v0__fill_1
XFILLER_78_310 VDD VDD VSS VSS gf180mcu_fd_sc_mcu7t5v0__fillcap_4
XFILLER_66_527 VDD VDD VSS VSS gf180mcu_fd_sc_mcu7t5v0__fillcap_16
XFILLER_19_465 VDD VDD VSS VSS gf180mcu_fd_sc_mcu7t5v0__fillcap_16
X_1030_ _2092_/Q _2137_/Q _1030_/Z VDD VDD VSS VSS gf180mcu_fd_sc_mcu7t5v0__xor2_1
XFILLER_74_560 VDD VDD VSS VSS gf180mcu_fd_sc_mcu7t5v0__fill_1
XFILLER_74_582 VDD VDD VSS VSS gf180mcu_fd_sc_mcu7t5v0__fill_1
XFILLER_34_457 VDD VDD VSS VSS gf180mcu_fd_sc_mcu7t5v0__fillcap_32
X_1932_ _1932_/D _2082_/RN _2082_/CLK _1932_/Q VDD VDD VSS VSS gf180mcu_fd_sc_mcu7t5v0__dffsnq_1
XFILLER_61_298 VDD VDD VSS VSS gf180mcu_fd_sc_mcu7t5v0__fillcap_4
X_1863_ _1863_/D _1886_/RN _2061_/CLK _1863_/Q VDD VDD VSS VSS gf180mcu_fd_sc_mcu7t5v0__dffrnq_1
Xinput20 cfg_data_i[22] input20/Z VDD VDD VSS VSS gf180mcu_fd_sc_mcu7t5v0__dlyb_1
Xinput31 cfg_data_i[3] input31/Z VDD VDD VSS VSS gf180mcu_fd_sc_mcu7t5v0__dlyb_1
X_1794_ _2075_/Q _1810_/A2 _1801_/B VDD VDD VSS VSS gf180mcu_fd_sc_mcu7t5v0__nand2_1
Xinput42 cfg_rx_bytes_left_i[12] input42/Z VDD VDD VSS VSS gf180mcu_fd_sc_mcu7t5v0__dlyb_1
Xinput53 cfg_rx_bytes_left_i[8] input53/Z VDD VDD VSS VSS gf180mcu_fd_sc_mcu7t5v0__dlyb_1
Xinput64 cfg_rx_curr_addr_i[7] input64/Z VDD VDD VSS VSS gf180mcu_fd_sc_mcu7t5v0__dlyb_1
Xmax_cap545 _1653_/S _1662_/S VDD VDD VSS VSS gf180mcu_fd_sc_mcu7t5v0__buf_2
Xmax_cap534 fanout346/Z _2151_/RN VDD VDD VSS VSS gf180mcu_fd_sc_mcu7t5v0__buf_2
Xinput97 cfg_tx_en_i input97/Z VDD VDD VSS VSS gf180mcu_fd_sc_mcu7t5v0__dlyb_1
Xinput86 cfg_tx_curr_addr_i[10] input86/Z VDD VDD VSS VSS gf180mcu_fd_sc_mcu7t5v0__dlyb_1
Xinput75 cfg_tx_bytes_left_i[15] input75/Z VDD VDD VSS VSS gf180mcu_fd_sc_mcu7t5v0__dlyb_1
XFILLER_6_380 VDD VDD VSS VSS gf180mcu_fd_sc_mcu7t5v0__fillcap_4
Xmax_cap556 _2128_/RN _1948_/RN VDD VDD VSS VSS gf180mcu_fd_sc_mcu7t5v0__buf_2
XFILLER_88_107 VDD VDD VSS VSS gf180mcu_fd_sc_mcu7t5v0__fillcap_64
XFILLER_97_685 VDD VDD VSS VSS gf180mcu_fd_sc_mcu7t5v0__fillcap_4
XFILLER_84_313 VDD VDD VSS VSS gf180mcu_fd_sc_mcu7t5v0__fill_2
X_1228_ _2140_/Q _1226_/Z _1230_/A2 VDD VDD VSS VSS gf180mcu_fd_sc_mcu7t5v0__nor2_1
XFILLER_25_413 VDD VDD VSS VSS gf180mcu_fd_sc_mcu7t5v0__fillcap_4
XFILLER_37_262 VDD VDD VSS VSS gf180mcu_fd_sc_mcu7t5v0__fillcap_16
XTAP_TAPCELL_ROW_55_739 VDD VSS gf180mcu_fd_sc_mcu7t5v0__filltie
XFILLER_16_37 VDD VDD VSS VSS gf180mcu_fd_sc_mcu7t5v0__fillcap_64
X_1159_ _1159_/A1 _1159_/A2 _1159_/A3 _1304_/A4 VDD VDD VSS VSS gf180mcu_fd_sc_mcu7t5v0__nand3_1
XFILLER_12_107 VDD VDD VSS VSS gf180mcu_fd_sc_mcu7t5v0__fillcap_16
XFILLER_21_663 VDD VDD VSS VSS gf180mcu_fd_sc_mcu7t5v0__fillcap_8
XFILLER_20_162 VDD VDD VSS VSS gf180mcu_fd_sc_mcu7t5v0__fillcap_8
XFILLER_32_69 VDD VDD VSS VSS gf180mcu_fd_sc_mcu7t5v0__fillcap_8
XTAP_TAPCELL_ROW_10_308 VDD VSS gf180mcu_fd_sc_mcu7t5v0__filltie
XFILLER_4_328 VDD VDD VSS VSS gf180mcu_fd_sc_mcu7t5v0__fillcap_8
XFILLER_4_317 VDD VDD VSS VSS gf180mcu_fd_sc_mcu7t5v0__fill_1
XFILLER_0_512 VDD VDD VSS VSS gf180mcu_fd_sc_mcu7t5v0__fillcap_32
XFILLER_79_107 VDD VDD VSS VSS gf180mcu_fd_sc_mcu7t5v0__fillcap_4
XFILLER_88_685 VDD VDD VSS VSS gf180mcu_fd_sc_mcu7t5v0__fill_1
XFILLER_75_302 VDD VDD VSS VSS gf180mcu_fd_sc_mcu7t5v0__fill_1
XFILLER_48_527 VDD VDD VSS VSS gf180mcu_fd_sc_mcu7t5v0__fillcap_8
XFILLER_75_324 VDD VDD VSS VSS gf180mcu_fd_sc_mcu7t5v0__fill_1
XFILLER_57_66 VDD VDD VSS VSS gf180mcu_fd_sc_mcu7t5v0__fillcap_4
XFILLER_16_424 VDD VDD VSS VSS gf180mcu_fd_sc_mcu7t5v0__fillcap_8
XFILLER_28_262 VDD VDD VSS VSS gf180mcu_fd_sc_mcu7t5v0__fillcap_32
XFILLER_16_457 VDD VDD VSS VSS gf180mcu_fd_sc_mcu7t5v0__fillcap_8
XFILLER_71_552 VDD VDD VSS VSS gf180mcu_fd_sc_mcu7t5v0__fill_2
XFILLER_31_405 VDD VDD VSS VSS gf180mcu_fd_sc_mcu7t5v0__fillcap_8
XTAP_TAPCELL_ROW_26_463 VDD VSS gf180mcu_fd_sc_mcu7t5v0__filltie
XFILLER_8_667 VDD VDD VSS VSS gf180mcu_fd_sc_mcu7t5v0__fillcap_16
XFILLER_78_140 VDD VDD VSS VSS gf180mcu_fd_sc_mcu7t5v0__fillcap_8
X_2131_ _2131_/D _2133_/RN _2133_/CLK _2131_/Q VDD VDD VSS VSS gf180mcu_fd_sc_mcu7t5v0__dffrnq_1
X_2062_ _2062_/D fanout458/Z clkload9/I _2062_/Q VDD VDD VSS VSS gf180mcu_fd_sc_mcu7t5v0__dffsnq_1
XFILLER_66_346 VDD VDD VSS VSS gf180mcu_fd_sc_mcu7t5v0__fillcap_8
X_1013_ _1935_/Q _1933_/Q _1932_/Q _1821_/C VDD VDD VSS VSS gf180mcu_fd_sc_mcu7t5v0__oai21_1
XTAP_TAPCELL_ROW_52_709 VDD VSS gf180mcu_fd_sc_mcu7t5v0__filltie
XFILLER_22_427 VDD VDD VSS VSS gf180mcu_fd_sc_mcu7t5v0__fill_2
XFILLER_22_449 VDD VDD VSS VSS gf180mcu_fd_sc_mcu7t5v0__fillcap_4
X_1915_ _1915_/D _1918_/RN _1951_/CLK _1915_/Q VDD VDD VSS VSS gf180mcu_fd_sc_mcu7t5v0__dffrnq_1
XTAP_TAPCELL_ROW_60_786 VDD VSS gf180mcu_fd_sc_mcu7t5v0__filltie
X_1846_ _1968_/Q _2093_/Q _1853_/S _2093_/D VDD VDD VSS VSS gf180mcu_fd_sc_mcu7t5v0__mux2_2
X_1777_ _1777_/A1 _1777_/A2 _1777_/B _1777_/C _2072_/D VDD VDD VSS VSS gf180mcu_fd_sc_mcu7t5v0__oai211_1
Xmax_cap342 _1306_/S0 _1311_/S0 VDD VDD VSS VSS gf180mcu_fd_sc_mcu7t5v0__buf_2
Xmax_cap331 _1734_/A2 _1700_/A2 VDD VDD VSS VSS gf180mcu_fd_sc_mcu7t5v0__dlyb_1
XPHY_EDGE_ROW_4_Right_4 VDD VSS gf180mcu_fd_sc_mcu7t5v0__endcap
XFILLER_89_438 VDD VDD VSS VSS gf180mcu_fd_sc_mcu7t5v0__fillcap_4
XFILLER_57_368 VDD VDD VSS VSS gf180mcu_fd_sc_mcu7t5v0__fill_1
XFILLER_85_688 VDD VDD VSS VSS gf180mcu_fd_sc_mcu7t5v0__fillcap_4
XFILLER_38_593 VDD VDD VSS VSS gf180mcu_fd_sc_mcu7t5v0__fill_2
XFILLER_53_574 VDD VDD VSS VSS gf180mcu_fd_sc_mcu7t5v0__fill_2
XFILLER_53_552 VDD VDD VSS VSS gf180mcu_fd_sc_mcu7t5v0__fillcap_8
XFILLER_25_298 VDD VDD VSS VSS gf180mcu_fd_sc_mcu7t5v0__fill_1
XFILLER_80_382 VDD VDD VSS VSS gf180mcu_fd_sc_mcu7t5v0__fill_2
XTAP_TAPCELL_ROW_23_433 VDD VSS gf180mcu_fd_sc_mcu7t5v0__filltie
XFILLER_40_279 VDD VDD VSS VSS gf180mcu_fd_sc_mcu7t5v0__fill_2
XFILLER_95_419 VDD VDD VSS VSS gf180mcu_fd_sc_mcu7t5v0__fill_1
XFILLER_68_87 VDD VDD VSS VSS gf180mcu_fd_sc_mcu7t5v0__fillcap_16
XTAP_TAPCELL_ROW_89_1055 VDD VSS gf180mcu_fd_sc_mcu7t5v0__filltie
XFILLER_76_655 VDD VDD VSS VSS gf180mcu_fd_sc_mcu7t5v0__fillcap_8
XFILLER_36_519 VDD VDD VSS VSS gf180mcu_fd_sc_mcu7t5v0__fillcap_4
XFILLER_75_198 VDD VDD VSS VSS gf180mcu_fd_sc_mcu7t5v0__fillcap_4
XFILLER_71_360 VDD VDD VSS VSS gf180mcu_fd_sc_mcu7t5v0__fill_2
Xclkbuf_5_15__f_sys_clk_i clkbuf_4_7_0_sys_clk_i/Z clkload3/I VDD VDD VSS VSS gf180mcu_fd_sc_mcu7t5v0__clkbuf_16
X_1700_ _2084_/Q _1700_/A2 _1700_/B _1702_/A2 VDD VDD VSS VSS gf180mcu_fd_sc_mcu7t5v0__aoi21_1
X_1631_ _2003_/Q input10/Z _1631_/S _2003_/D VDD VDD VSS VSS gf180mcu_fd_sc_mcu7t5v0__mux2_2
X_1562_ _1941_/Q _1570_/I0 _1565_/S _1941_/D VDD VDD VSS VSS gf180mcu_fd_sc_mcu7t5v0__mux2_2
X_1493_ _1511_/B _1468_/Z _1511_/C _1523_/A2 VDD VDD VSS VSS gf180mcu_fd_sc_mcu7t5v0__nand3_1
XFILLER_27_508 VDD VDD VSS VSS gf180mcu_fd_sc_mcu7t5v0__fill_2
X_2114_ _2114_/D _2115_/RN _2153_/CLK _2114_/Q VDD VDD VSS VSS gf180mcu_fd_sc_mcu7t5v0__dffrnq_1
XFILLER_67_688 VDD VDD VSS VSS gf180mcu_fd_sc_mcu7t5v0__fillcap_4
XFILLER_66_187 VDD VDD VSS VSS gf180mcu_fd_sc_mcu7t5v0__fillcap_8
X_2045_ _2045_/D _2188_/RN clkload3/I _2045_/Q VDD VDD VSS VSS gf180mcu_fd_sc_mcu7t5v0__dffrnq_1
XTAP_TAPCELL_ROW_65_834 VDD VSS gf180mcu_fd_sc_mcu7t5v0__filltie
Xclkbuf_4_12_0_sys_clk_i clkbuf_0_sys_clk_i/Z clkbuf_4_12_0_sys_clk_i/Z VDD VDD VSS
+ VSS gf180mcu_fd_sc_mcu7t5v0__clkbuf_2
XFILLER_90_691 VDD VDD VSS VSS gf180mcu_fd_sc_mcu7t5v0__fill_2
XFILLER_10_408 VDD VDD VSS VSS gf180mcu_fd_sc_mcu7t5v0__fill_1
XFILLER_50_577 VDD VDD VSS VSS gf180mcu_fd_sc_mcu7t5v0__fillcap_16
XTAP_TAPCELL_ROW_20_403 VDD VSS gf180mcu_fd_sc_mcu7t5v0__filltie
X_1829_ _1739_/B _1829_/A2 _1829_/A3 _1832_/A2 _1830_/A3 VDD VDD VSS VSS gf180mcu_fd_sc_mcu7t5v0__nand4_1
XFILLER_77_419 VDD VDD VSS VSS gf180mcu_fd_sc_mcu7t5v0__fill_1
XPHY_EDGE_ROW_79_Right_79 VDD VSS gf180mcu_fd_sc_mcu7t5v0__endcap
XFILLER_72_102 VDD VDD VSS VSS gf180mcu_fd_sc_mcu7t5v0__fill_2
XFILLER_57_187 VDD VDD VSS VSS gf180mcu_fd_sc_mcu7t5v0__fillcap_8
XFILLER_57_154 VDD VDD VSS VSS gf180mcu_fd_sc_mcu7t5v0__fill_1
XFILLER_41_500 VDD VDD VSS VSS gf180mcu_fd_sc_mcu7t5v0__fillcap_4
XFILLER_81_680 VDD VDD VSS VSS gf180mcu_fd_sc_mcu7t5v0__fillcap_8
XFILLER_13_257 VDD VDD VSS VSS gf180mcu_fd_sc_mcu7t5v0__fillcap_4
XFILLER_70_33 VDD VDD VSS VSS gf180mcu_fd_sc_mcu7t5v0__fill_2
XPHY_EDGE_ROW_88_Right_88 VDD VSS gf180mcu_fd_sc_mcu7t5v0__endcap
XFILLER_5_489 VDD VDD VSS VSS gf180mcu_fd_sc_mcu7t5v0__fill_1
XTAP_TAPCELL_ROW_79_959 VDD VSS gf180mcu_fd_sc_mcu7t5v0__filltie
XPHY_EDGE_ROW_97_Right_97 VDD VSS gf180mcu_fd_sc_mcu7t5v0__endcap
XFILLER_76_441 VDD VDD VSS VSS gf180mcu_fd_sc_mcu7t5v0__fill_1
XFILLER_36_349 VDD VDD VSS VSS gf180mcu_fd_sc_mcu7t5v0__fill_2
XFILLER_63_124 VDD VDD VSS VSS gf180mcu_fd_sc_mcu7t5v0__fill_1
XFILLER_17_541 VDD VDD VSS VSS gf180mcu_fd_sc_mcu7t5v0__fillcap_16
XTAP_TAPCELL_ROW_62_804 VDD VSS gf180mcu_fd_sc_mcu7t5v0__filltie
XFILLER_91_488 VDD VDD VSS VSS gf180mcu_fd_sc_mcu7t5v0__fill_2
XFILLER_51_308 VDD VDD VSS VSS gf180mcu_fd_sc_mcu7t5v0__fill_1
XFILLER_17_596 VDD VDD VSS VSS gf180mcu_fd_sc_mcu7t5v0__fill_2
XTAP_TAPCELL_ROW_34_539 VDD VSS gf180mcu_fd_sc_mcu7t5v0__filltie
XFILLER_72_691 VDD VDD VSS VSS gf180mcu_fd_sc_mcu7t5v0__fill_2
XFILLER_44_371 VDD VDD VSS VSS gf180mcu_fd_sc_mcu7t5v0__fillcap_8
X_0993_ _1578_/A1 _1957_/Q _1557_/A1 VDD VDD VSS VSS gf180mcu_fd_sc_mcu7t5v0__nand2_1
XTAP_TAPCELL_ROW_70_881 VDD VSS gf180mcu_fd_sc_mcu7t5v0__filltie
X_1614_ input37/Z _1987_/Q _1616_/S _1987_/D VDD VDD VSS VSS gf180mcu_fd_sc_mcu7t5v0__mux2_2
X_1545_ _1934_/Q _1935_/Q _1545_/S _1935_/D VDD VDD VSS VSS gf180mcu_fd_sc_mcu7t5v0__mux2_2
XFILLER_5_50 VDD VDD VSS VSS gf180mcu_fd_sc_mcu7t5v0__fillcap_8
X_1476_ _1499_/A1 _1904_/Q _1479_/A1 VDD VDD VSS VSS gf180mcu_fd_sc_mcu7t5v0__nand2_1
Xclkbuf_5_31__f_periph_clk_i clkbuf_4_15_0_periph_clk_i/Z _2176_/CLK VDD VDD VSS VSS
+ gf180mcu_fd_sc_mcu7t5v0__clkbuf_16
XFILLER_79_290 VDD VDD VSS VSS gf180mcu_fd_sc_mcu7t5v0__fillcap_4
XFILLER_67_430 VDD VDD VSS VSS gf180mcu_fd_sc_mcu7t5v0__fillcap_16
XFILLER_94_271 VDD VDD VSS VSS gf180mcu_fd_sc_mcu7t5v0__fillcap_4
XFILLER_82_433 VDD VDD VSS VSS gf180mcu_fd_sc_mcu7t5v0__fill_1
X_2028_ _2028_/D _2028_/RN _2128_/CLK _2028_/Q VDD VDD VSS VSS gf180mcu_fd_sc_mcu7t5v0__dffrnq_1
XFILLER_23_522 VDD VDD VSS VSS gf180mcu_fd_sc_mcu7t5v0__fillcap_32
XFILLER_35_360 VDD VDD VSS VSS gf180mcu_fd_sc_mcu7t5v0__fillcap_4
XFILLER_63_680 VDD VDD VSS VSS gf180mcu_fd_sc_mcu7t5v0__fillcap_8
XFILLER_23_566 VDD VDD VSS VSS gf180mcu_fd_sc_mcu7t5v0__fill_2
XFILLER_24_37 VDD VDD VSS VSS gf180mcu_fd_sc_mcu7t5v0__fillcap_8
XFILLER_6_6 VDD VDD VSS VSS gf180mcu_fd_sc_mcu7t5v0__fillcap_16
XTAP_TAPCELL_ROW_5_264 VDD VSS gf180mcu_fd_sc_mcu7t5v0__filltie
XFILLER_58_452 VDD VDD VSS VSS gf180mcu_fd_sc_mcu7t5v0__fill_2
XTAP_TAPCELL_ROW_86_1025 VDD VSS gf180mcu_fd_sc_mcu7t5v0__filltie
XFILLER_85_282 VDD VDD VSS VSS gf180mcu_fd_sc_mcu7t5v0__fillcap_8
XFILLER_73_422 VDD VDD VSS VSS gf180mcu_fd_sc_mcu7t5v0__fillcap_16
XFILLER_14_500 VDD VDD VSS VSS gf180mcu_fd_sc_mcu7t5v0__fillcap_16
XFILLER_54_691 VDD VDD VSS VSS gf180mcu_fd_sc_mcu7t5v0__fill_2
XFILLER_14_577 VDD VDD VSS VSS gf180mcu_fd_sc_mcu7t5v0__fillcap_4
XTAP_TAPCELL_ROW_31_509 VDD VSS gf180mcu_fd_sc_mcu7t5v0__filltie
XFILLER_41_352 VDD VDD VSS VSS gf180mcu_fd_sc_mcu7t5v0__fillcap_64
XTAP_TAPCELL_ROW_97_1132 VDD VSS gf180mcu_fd_sc_mcu7t5v0__filltie
X_1330_ input38/Z _1319_/C _1332_/A3 _1353_/A1 VDD VDD VSS VSS gf180mcu_fd_sc_mcu7t5v0__nand3_1
XFILLER_1_492 VDD VDD VSS VSS gf180mcu_fd_sc_mcu7t5v0__fillcap_64
X_1261_ _2161_/Q _2162_/Q _2163_/Q _2164_/Q _1270_/A4 VDD VDD VSS VSS gf180mcu_fd_sc_mcu7t5v0__nand4_1
Xinput7 cfg_data_i[10] input7/Z VDD VDD VSS VSS gf180mcu_fd_sc_mcu7t5v0__dlyb_1
X_1192_ _1195_/A1 _1972_/Q _1195_/A3 _1195_/A4 _1192_/Z VDD VDD VSS VSS gf180mcu_fd_sc_mcu7t5v0__and4_1
Xclkbuf_5_10__f_periph_clk_i clkbuf_4_5_0_periph_clk_i/Z _2155_/CLK VDD VDD VSS VSS
+ gf180mcu_fd_sc_mcu7t5v0__clkbuf_16
XFILLER_60_683 VDD VDD VSS VSS gf180mcu_fd_sc_mcu7t5v0__fillcap_8
XFILLER_60_661 VDD VDD VSS VSS gf180mcu_fd_sc_mcu7t5v0__fillcap_4
XFILLER_20_569 VDD VDD VSS VSS gf180mcu_fd_sc_mcu7t5v0__fill_1
X_0976_ _0906_/I _0968_/Z _1673_/A3 _1604_/A4 _1665_/S VDD VDD VSS VSS gf180mcu_fd_sc_mcu7t5v0__nand4_1
X_1528_ _2122_/D _2125_/D _1531_/S _1928_/D VDD VDD VSS VSS gf180mcu_fd_sc_mcu7t5v0__mux2_2
X_1459_ _1458_/Z _1896_/Q _1473_/S _1896_/D VDD VDD VSS VSS gf180mcu_fd_sc_mcu7t5v0__mux2_2
XFILLER_87_547 VDD VDD VSS VSS gf180mcu_fd_sc_mcu7t5v0__fillcap_8
XTAP_TAPCELL_ROW_2_234 VDD VSS gf180mcu_fd_sc_mcu7t5v0__filltie
XFILLER_67_282 VDD VDD VSS VSS gf180mcu_fd_sc_mcu7t5v0__fillcap_16
XFILLER_55_422 VDD VDD VSS VSS gf180mcu_fd_sc_mcu7t5v0__fillcap_4
XFILLER_15_308 VDD VDD VSS VSS gf180mcu_fd_sc_mcu7t5v0__fill_2
XFILLER_55_477 VDD VDD VSS VSS gf180mcu_fd_sc_mcu7t5v0__fillcap_8
XFILLER_70_414 VDD VDD VSS VSS gf180mcu_fd_sc_mcu7t5v0__fillcap_32
XFILLER_23_330 VDD VDD VSS VSS gf180mcu_fd_sc_mcu7t5v0__fillcap_4
XFILLER_35_69 VDD VDD VSS VSS gf180mcu_fd_sc_mcu7t5v0__fill_1
XFILLER_70_469 VDD VDD VSS VSS gf180mcu_fd_sc_mcu7t5v0__fill_2
XFILLER_23_352 VDD VDD VSS VSS gf180mcu_fd_sc_mcu7t5v0__fillcap_64
XFILLER_51_672 VDD VDD VSS VSS gf180mcu_fd_sc_mcu7t5v0__fill_2
Xwire405 wire405/I cfg_rx_size_o[1] VDD VDD VSS VSS gf180mcu_fd_sc_mcu7t5v0__clkbuf_3
Xclkbuf_5_3__f_sys_clk_i clkbuf_4_1_0_sys_clk_i/Z _2021_/CLK VDD VDD VSS VSS gf180mcu_fd_sc_mcu7t5v0__clkbuf_16
XTAP_TAPCELL_ROW_92_1084 VDD VSS gf180mcu_fd_sc_mcu7t5v0__filltie
XFILLER_18_157 VDD VDD VSS VSS gf180mcu_fd_sc_mcu7t5v0__fill_2
XTAP_TAPCELL_ROW_44_634 VDD VSS gf180mcu_fd_sc_mcu7t5v0__filltie
XFILLER_14_341 VDD VDD VSS VSS gf180mcu_fd_sc_mcu7t5v0__fillcap_4
XTAP_TAPCELL_ROW_16_369 VDD VSS gf180mcu_fd_sc_mcu7t5v0__filltie
XFILLER_10_580 VDD VDD VSS VSS gf180mcu_fd_sc_mcu7t5v0__fillcap_8
XFILLER_96_311 VDD VDD VSS VSS gf180mcu_fd_sc_mcu7t5v0__fillcap_4
XFILLER_69_514 VDD VDD VSS VSS gf180mcu_fd_sc_mcu7t5v0__fill_1
X_1313_ _1756_/A1 _1831_/A4 _1313_/Z VDD VDD VSS VSS gf180mcu_fd_sc_mcu7t5v0__and2_1
XPHY_EDGE_ROW_16_Left_115 VDD VSS gf180mcu_fd_sc_mcu7t5v0__endcap
X_1244_ _1247_/A1 _1244_/A2 _1243_/Z _2144_/D VDD VDD VSS VSS gf180mcu_fd_sc_mcu7t5v0__nor3_1
XFILLER_37_411 VDD VDD VSS VSS gf180mcu_fd_sc_mcu7t5v0__fillcap_8
XFILLER_37_422 VDD VDD VSS VSS gf180mcu_fd_sc_mcu7t5v0__fill_2
XFILLER_49_282 VDD VDD VSS VSS gf180mcu_fd_sc_mcu7t5v0__fillcap_8
XFILLER_49_271 VDD VDD VSS VSS gf180mcu_fd_sc_mcu7t5v0__fill_2
X_1175_ _1338_/A2 _0906_/I _1604_/A4 _1354_/A3 VDD VDD VSS VSS gf180mcu_fd_sc_mcu7t5v0__nor3_1
XFILLER_64_241 VDD VDD VSS VSS gf180mcu_fd_sc_mcu7t5v0__fillcap_4
XFILLER_25_628 VDD VDD VSS VSS gf180mcu_fd_sc_mcu7t5v0__fill_2
XFILLER_64_263 VDD VDD VSS VSS gf180mcu_fd_sc_mcu7t5v0__fillcap_8
XFILLER_17_190 VDD VDD VSS VSS gf180mcu_fd_sc_mcu7t5v0__fill_1
XFILLER_52_447 VDD VDD VSS VSS gf180mcu_fd_sc_mcu7t5v0__fill_2
XPHY_EDGE_ROW_25_Left_124 VDD VSS gf180mcu_fd_sc_mcu7t5v0__endcap
XFILLER_20_366 VDD VDD VSS VSS gf180mcu_fd_sc_mcu7t5v0__fillcap_16
XFILLER_20_399 VDD VDD VSS VSS gf180mcu_fd_sc_mcu7t5v0__fillcap_4
X_0959_ _2084_/Q _1754_/A2 VDD VDD VSS VSS gf180mcu_fd_sc_mcu7t5v0__clkinv_1
Xoutput152 _2003_/Q wire408/I VDD VDD VSS VSS gf180mcu_fd_sc_mcu7t5v0__buf_1
Xoutput141 _1382_/ZN wire241/I VDD VDD VSS VSS gf180mcu_fd_sc_mcu7t5v0__buf_1
Xoutput130 _1189_/Z wire300/I VDD VDD VSS VSS gf180mcu_fd_sc_mcu7t5v0__buf_1
Xoutput185 _2034_/Q wire375/I VDD VDD VSS VSS gf180mcu_fd_sc_mcu7t5v0__buf_1
Xoutput174 _1986_/Q wire386/I VDD VDD VSS VSS gf180mcu_fd_sc_mcu7t5v0__buf_1
Xoutput163 _1999_/Q wire397/I VDD VDD VSS VSS gf180mcu_fd_sc_mcu7t5v0__buf_1
XPHY_EDGE_ROW_34_Left_133 VDD VSS gf180mcu_fd_sc_mcu7t5v0__endcap
Xoutput196 _2017_/Q wire364/I VDD VDD VSS VSS gf180mcu_fd_sc_mcu7t5v0__buf_1
XFILLER_68_580 VDD VDD VSS VSS gf180mcu_fd_sc_mcu7t5v0__fillcap_8
XTAP_TAPCELL_ROW_58_759 VDD VSS gf180mcu_fd_sc_mcu7t5v0__filltie
XTAP_TAPCELL_ROW_41_604 VDD VSS gf180mcu_fd_sc_mcu7t5v0__filltie
XPHY_EDGE_ROW_43_Left_142 VDD VSS gf180mcu_fd_sc_mcu7t5v0__endcap
XFILLER_62_45 VDD VDD VSS VSS gf180mcu_fd_sc_mcu7t5v0__fillcap_4
XFILLER_62_34 VDD VDD VSS VSS gf180mcu_fd_sc_mcu7t5v0__fill_1
XFILLER_43_469 VDD VDD VSS VSS gf180mcu_fd_sc_mcu7t5v0__fillcap_16
XTAP_TAPCELL_ROW_13_339 VDD VSS gf180mcu_fd_sc_mcu7t5v0__filltie
XFILLER_11_399 VDD VDD VSS VSS gf180mcu_fd_sc_mcu7t5v0__fillcap_4
Xwire246 wire246/I cfg_data_o[12] VDD VDD VSS VSS gf180mcu_fd_sc_mcu7t5v0__clkbuf_3
Xwire224 wire224/I cfg_data_o[5] VDD VDD VSS VSS gf180mcu_fd_sc_mcu7t5v0__clkbuf_3
XTAP_TAPCELL_ROW_94_1102 VDD VSS gf180mcu_fd_sc_mcu7t5v0__filltie
XPHY_EDGE_ROW_52_Left_151 VDD VSS gf180mcu_fd_sc_mcu7t5v0__endcap
Xload_slew229 _1681_/S _1684_/S VDD VDD VSS VSS gf180mcu_fd_sc_mcu7t5v0__buf_2
XFILLER_46_241 VDD VDD VSS VSS gf180mcu_fd_sc_mcu7t5v0__fillcap_4
XFILLER_74_572 VDD VDD VSS VSS gf180mcu_fd_sc_mcu7t5v0__fillcap_8
XPHY_EDGE_ROW_61_Left_160 VDD VSS gf180mcu_fd_sc_mcu7t5v0__endcap
XFILLER_61_277 VDD VDD VSS VSS gf180mcu_fd_sc_mcu7t5v0__fill_2
XFILLER_61_266 VDD VDD VSS VSS gf180mcu_fd_sc_mcu7t5v0__fill_2
X_1931_ _1931_/D _2126_/RN clkload4/I _2125_/D VDD VDD VSS VSS gf180mcu_fd_sc_mcu7t5v0__dffsnq_1
XFILLER_14_193 VDD VDD VSS VSS gf180mcu_fd_sc_mcu7t5v0__fill_2
X_1862_ _1862_/D _1886_/RN _2188_/CLK _1862_/Q VDD VDD VSS VSS gf180mcu_fd_sc_mcu7t5v0__dffrnq_1
Xinput10 cfg_data_i[13] input10/Z VDD VDD VSS VSS gf180mcu_fd_sc_mcu7t5v0__dlyb_1
Xinput21 cfg_data_i[23] input21/Z VDD VDD VSS VSS gf180mcu_fd_sc_mcu7t5v0__dlyb_1
X_1793_ _1793_/A1 _1793_/A2 _1793_/B _1793_/C _2074_/D VDD VDD VSS VSS gf180mcu_fd_sc_mcu7t5v0__oai211_1
Xinput32 cfg_data_i[4] input32/Z VDD VDD VSS VSS gf180mcu_fd_sc_mcu7t5v0__dlyb_1
Xinput43 cfg_rx_bytes_left_i[13] input43/Z VDD VDD VSS VSS gf180mcu_fd_sc_mcu7t5v0__dlyb_1
Xinput54 cfg_rx_bytes_left_i[9] input54/Z VDD VDD VSS VSS gf180mcu_fd_sc_mcu7t5v0__dlyb_1
Xmax_cap535 _1577_/A1 _1531_/S VDD VDD VSS VSS gf180mcu_fd_sc_mcu7t5v0__buf_2
Xinput98 cfg_tx_pending_i input98/Z VDD VDD VSS VSS gf180mcu_fd_sc_mcu7t5v0__dlyb_1
Xinput87 cfg_tx_curr_addr_i[11] input87/Z VDD VDD VSS VSS gf180mcu_fd_sc_mcu7t5v0__dlyb_1
Xinput76 cfg_tx_bytes_left_i[1] input76/Z VDD VDD VSS VSS gf180mcu_fd_sc_mcu7t5v0__dlyb_1
Xinput65 cfg_rx_curr_addr_i[8] input65/Z VDD VDD VSS VSS gf180mcu_fd_sc_mcu7t5v0__dlyb_1
Xmax_cap557 _2032_/RN _2025_/RN VDD VDD VSS VSS gf180mcu_fd_sc_mcu7t5v0__buf_2
Xmax_cap546 _2194_/RN _2193_/RN VDD VDD VSS VSS gf180mcu_fd_sc_mcu7t5v0__buf_2
XFILLER_97_653 VDD VDD VSS VSS gf180mcu_fd_sc_mcu7t5v0__fillcap_32
XFILLER_69_333 VDD VDD VSS VSS gf180mcu_fd_sc_mcu7t5v0__fillcap_16
Xclkbuf_5_22__f_sys_clk_i clkbuf_4_11_0_sys_clk_i/Z _1951_/CLK VDD VDD VSS VSS gf180mcu_fd_sc_mcu7t5v0__clkbuf_16
XFILLER_69_399 VDD VDD VSS VSS gf180mcu_fd_sc_mcu7t5v0__fill_2
XFILLER_69_388 VDD VDD VSS VSS gf180mcu_fd_sc_mcu7t5v0__fill_2
X_1227_ _1230_/A1 _1227_/A2 _1226_/Z _2139_/D VDD VDD VSS VSS gf180mcu_fd_sc_mcu7t5v0__nor3_1
X_1158_ _1158_/A1 _1158_/A2 _1158_/A3 _1159_/A2 VDD VDD VSS VSS gf180mcu_fd_sc_mcu7t5v0__nor3_1
XFILLER_52_244 VDD VDD VSS VSS gf180mcu_fd_sc_mcu7t5v0__fill_1
X_1089_ _2097_/Q _2173_/Q _1089_/Z VDD VDD VSS VSS gf180mcu_fd_sc_mcu7t5v0__or2_1
XFILLER_80_597 VDD VDD VSS VSS gf180mcu_fd_sc_mcu7t5v0__fillcap_64
XFILLER_20_130 VDD VDD VSS VSS gf180mcu_fd_sc_mcu7t5v0__fillcap_32
XFILLER_32_37 VDD VDD VSS VSS gf180mcu_fd_sc_mcu7t5v0__fillcap_32
XFILLER_20_174 VDD VDD VSS VSS gf180mcu_fd_sc_mcu7t5v0__fill_1
XTAP_TAPCELL_ROW_10_309 VDD VSS gf180mcu_fd_sc_mcu7t5v0__filltie
XFILLER_0_546 VDD VDD VSS VSS gf180mcu_fd_sc_mcu7t5v0__fillcap_32
XFILLER_75_314 VDD VDD VSS VSS gf180mcu_fd_sc_mcu7t5v0__fillcap_8
XFILLER_28_241 VDD VDD VSS VSS gf180mcu_fd_sc_mcu7t5v0__fillcap_4
XFILLER_90_317 VDD VDD VSS VSS gf180mcu_fd_sc_mcu7t5v0__fillcap_8
XFILLER_31_417 VDD VDD VSS VSS gf180mcu_fd_sc_mcu7t5v0__fill_2
XTAP_TAPCELL_ROW_26_464 VDD VSS gf180mcu_fd_sc_mcu7t5v0__filltie
XFILLER_71_586 VDD VDD VSS VSS gf180mcu_fd_sc_mcu7t5v0__fillcap_4
XFILLER_3_340 VDD VDD VSS VSS gf180mcu_fd_sc_mcu7t5v0__fillcap_4
XFILLER_78_152 VDD VDD VSS VSS gf180mcu_fd_sc_mcu7t5v0__fill_2
X_2130_ _2130_/D _2130_/RN _2130_/CLK _2130_/Q VDD VDD VSS VSS gf180mcu_fd_sc_mcu7t5v0__dffrnq_1
XFILLER_78_185 VDD VDD VSS VSS gf180mcu_fd_sc_mcu7t5v0__fill_2
XFILLER_78_174 VDD VDD VSS VSS gf180mcu_fd_sc_mcu7t5v0__fill_1
X_2061_ _2061_/D _2101_/RN _2061_/CLK _2061_/Q VDD VDD VSS VSS gf180mcu_fd_sc_mcu7t5v0__dffsnq_1
XFILLER_94_667 VDD VDD VSS VSS gf180mcu_fd_sc_mcu7t5v0__fillcap_16
XFILLER_66_358 VDD VDD VSS VSS gf180mcu_fd_sc_mcu7t5v0__fill_2
X_1012_ _1813_/A1 _1789_/A2 _1012_/ZN VDD VDD VSS VSS gf180mcu_fd_sc_mcu7t5v0__nand2_1
Xclkbuf_4_11_0_sys_clk_i clkbuf_0_sys_clk_i/Z clkbuf_4_11_0_sys_clk_i/Z VDD VDD VSS
+ VSS gf180mcu_fd_sc_mcu7t5v0__clkbuf_2
XFILLER_22_439 VDD VDD VSS VSS gf180mcu_fd_sc_mcu7t5v0__fill_1
XFILLER_97_2 VDD VDD VSS VSS gf180mcu_fd_sc_mcu7t5v0__fillcap_64
XFILLER_62_597 VDD VDD VSS VSS gf180mcu_fd_sc_mcu7t5v0__fillcap_64
X_1914_ _1914_/D _1951_/RN _1951_/CLK _1914_/Q VDD VDD VSS VSS gf180mcu_fd_sc_mcu7t5v0__dffrnq_1
XTAP_TAPCELL_ROW_60_787 VDD VSS gf180mcu_fd_sc_mcu7t5v0__filltie
X_1845_ _1967_/Q _2092_/Q _1848_/S _2092_/D VDD VDD VSS VSS gf180mcu_fd_sc_mcu7t5v0__mux2_2
X_1776_ _1822_/B _1776_/A2 _1777_/A2 VDD VDD VSS VSS gf180mcu_fd_sc_mcu7t5v0__nand2_1
XFILLER_89_406 VDD VDD VSS VSS gf180mcu_fd_sc_mcu7t5v0__fillcap_8
XFILLER_69_174 VDD VDD VSS VSS gf180mcu_fd_sc_mcu7t5v0__fillcap_8
XTAP_TAPCELL_ROW_68_854 VDD VSS gf180mcu_fd_sc_mcu7t5v0__filltie
XFILLER_57_347 VDD VDD VSS VSS gf180mcu_fd_sc_mcu7t5v0__fill_2
XFILLER_84_177 VDD VDD VSS VSS gf180mcu_fd_sc_mcu7t5v0__fillcap_64
XFILLER_72_317 VDD VDD VSS VSS gf180mcu_fd_sc_mcu7t5v0__fill_2
XFILLER_72_306 VDD VDD VSS VSS gf180mcu_fd_sc_mcu7t5v0__fill_1
XFILLER_38_561 VDD VDD VSS VSS gf180mcu_fd_sc_mcu7t5v0__fillcap_32
XFILLER_13_417 VDD VDD VSS VSS gf180mcu_fd_sc_mcu7t5v0__fill_2
XFILLER_43_47 VDD VDD VSS VSS gf180mcu_fd_sc_mcu7t5v0__fill_1
XTAP_TAPCELL_ROW_23_434 VDD VSS gf180mcu_fd_sc_mcu7t5v0__filltie
XFILLER_43_69 VDD VDD VSS VSS gf180mcu_fd_sc_mcu7t5v0__fill_1
XFILLER_40_247 VDD VDD VSS VSS gf180mcu_fd_sc_mcu7t5v0__fillcap_16
XFILLER_0_376 VDD VDD VSS VSS gf180mcu_fd_sc_mcu7t5v0__fill_2
XFILLER_48_314 VDD VDD VSS VSS gf180mcu_fd_sc_mcu7t5v0__fill_1
XFILLER_76_667 VDD VDD VSS VSS gf180mcu_fd_sc_mcu7t5v0__fillcap_16
XTAP_TAPCELL_ROW_89_1056 VDD VSS gf180mcu_fd_sc_mcu7t5v0__filltie
XFILLER_91_626 VDD VDD VSS VSS gf180mcu_fd_sc_mcu7t5v0__fillcap_4
XFILLER_16_255 VDD VDD VSS VSS gf180mcu_fd_sc_mcu7t5v0__fill_1
XFILLER_71_372 VDD VDD VSS VSS gf180mcu_fd_sc_mcu7t5v0__fillcap_32
XFILLER_44_597 VDD VDD VSS VSS gf180mcu_fd_sc_mcu7t5v0__fillcap_8
XFILLER_8_454 VDD VDD VSS VSS gf180mcu_fd_sc_mcu7t5v0__fill_1
X_1630_ _2002_/Q input9/Z _1633_/S _2002_/D VDD VDD VSS VSS gf180mcu_fd_sc_mcu7t5v0__mux2_2
XFILLER_8_465 VDD VDD VSS VSS gf180mcu_fd_sc_mcu7t5v0__fillcap_4
X_1561_ _1940_/Q _1569_/I0 _1561_/S _1940_/D VDD VDD VSS VSS gf180mcu_fd_sc_mcu7t5v0__mux2_2
X_1492_ _1499_/A1 _1909_/Q _1494_/B VDD VDD VSS VSS gf180mcu_fd_sc_mcu7t5v0__nand2_1
XFILLER_67_623 VDD VDD VSS VSS gf180mcu_fd_sc_mcu7t5v0__fillcap_4
XFILLER_12_2 VDD VDD VSS VSS gf180mcu_fd_sc_mcu7t5v0__fillcap_32
X_2113_ _2113_/D _2115_/RN clkload1/I _2113_/Q VDD VDD VSS VSS gf180mcu_fd_sc_mcu7t5v0__dffrnq_1
XFILLER_66_133 VDD VDD VSS VSS gf180mcu_fd_sc_mcu7t5v0__fillcap_4
XFILLER_66_177 VDD VDD VSS VSS gf180mcu_fd_sc_mcu7t5v0__fillcap_4
XFILLER_54_317 VDD VDD VSS VSS gf180mcu_fd_sc_mcu7t5v0__fillcap_4
X_2044_ _2044_/D _0904_/I _2116_/CLK _2044_/Q VDD VDD VSS VSS gf180mcu_fd_sc_mcu7t5v0__dffrnq_1
XFILLER_82_648 VDD VDD VSS VSS gf180mcu_fd_sc_mcu7t5v0__fillcap_16
XFILLER_66_199 VDD VDD VSS VSS gf180mcu_fd_sc_mcu7t5v0__fill_2
XFILLER_22_236 VDD VDD VSS VSS gf180mcu_fd_sc_mcu7t5v0__fillcap_8
XFILLER_22_247 VDD VDD VSS VSS gf180mcu_fd_sc_mcu7t5v0__fillcap_16
XTAP_TAPCELL_ROW_20_404 VDD VSS gf180mcu_fd_sc_mcu7t5v0__filltie
X_1828_ _1830_/A2 _1828_/A2 _1828_/B _2080_/D VDD VDD VSS VSS gf180mcu_fd_sc_mcu7t5v0__aoi21_1
X_1759_ _2069_/Q _1832_/A2 _1831_/A4 _1826_/B VDD VDD VSS VSS gf180mcu_fd_sc_mcu7t5v0__nand3_1
Xclkbuf_5_8__f_sys_clk_i clkbuf_4_4_0_sys_clk_i/Z _2153_/CLK VDD VDD VSS VSS gf180mcu_fd_sc_mcu7t5v0__clkbuf_16
XPHY_EDGE_ROW_8_Left_107 VDD VSS gf180mcu_fd_sc_mcu7t5v0__endcap
XFILLER_58_612 VDD VDD VSS VSS gf180mcu_fd_sc_mcu7t5v0__fill_1
XFILLER_58_667 VDD VDD VSS VSS gf180mcu_fd_sc_mcu7t5v0__fillcap_16
XFILLER_38_47 VDD VDD VSS VSS gf180mcu_fd_sc_mcu7t5v0__fill_1
XFILLER_73_615 VDD VDD VSS VSS gf180mcu_fd_sc_mcu7t5v0__fillcap_8
XFILLER_57_199 VDD VDD VSS VSS gf180mcu_fd_sc_mcu7t5v0__fill_1
XFILLER_72_158 VDD VDD VSS VSS gf180mcu_fd_sc_mcu7t5v0__fill_2
XFILLER_54_57 VDD VDD VSS VSS gf180mcu_fd_sc_mcu7t5v0__fill_1
XFILLER_26_597 VDD VDD VSS VSS gf180mcu_fd_sc_mcu7t5v0__fillcap_4
XFILLER_81_692 VDD VDD VSS VSS gf180mcu_fd_sc_mcu7t5v0__fill_2
XFILLER_13_236 VDD VDD VSS VSS gf180mcu_fd_sc_mcu7t5v0__fill_1
XFILLER_9_229 VDD VDD VSS VSS gf180mcu_fd_sc_mcu7t5v0__fill_1
XFILLER_95_206 VDD VDD VSS VSS gf180mcu_fd_sc_mcu7t5v0__fillcap_4
XFILLER_79_98 VDD VDD VSS VSS gf180mcu_fd_sc_mcu7t5v0__fill_1
XTAP_TAPCELL_ROW_8_284 VDD VSS gf180mcu_fd_sc_mcu7t5v0__filltie
XFILLER_36_317 VDD VDD VSS VSS gf180mcu_fd_sc_mcu7t5v0__fillcap_32
XFILLER_48_177 VDD VDD VSS VSS gf180mcu_fd_sc_mcu7t5v0__fillcap_16
XFILLER_48_155 VDD VDD VSS VSS gf180mcu_fd_sc_mcu7t5v0__fillcap_8
XTAP_TAPCELL_ROW_62_805 VDD VSS gf180mcu_fd_sc_mcu7t5v0__filltie
XFILLER_44_383 VDD VDD VSS VSS gf180mcu_fd_sc_mcu7t5v0__fill_2
X_0992_ _1449_/B _0992_/ZN VDD VDD VSS VSS gf180mcu_fd_sc_mcu7t5v0__clkinv_1
XTAP_TAPCELL_ROW_70_882 VDD VSS gf180mcu_fd_sc_mcu7t5v0__filltie
XFILLER_8_262 VDD VDD VSS VSS gf180mcu_fd_sc_mcu7t5v0__fill_2
X_1613_ input36/Z _1986_/Q _1616_/S _1986_/D VDD VDD VSS VSS gf180mcu_fd_sc_mcu7t5v0__mux2_2
X_1544_ _1933_/Q _1934_/Q _1545_/S _1934_/D VDD VDD VSS VSS gf180mcu_fd_sc_mcu7t5v0__mux2_2
XFILLER_5_62 VDD VDD VSS VSS gf180mcu_fd_sc_mcu7t5v0__fill_2
X_1475_ _2123_/D _2122_/D _1475_/A3 _1577_/A1 _1499_/A1 VDD VDD VSS VSS gf180mcu_fd_sc_mcu7t5v0__nand4_2
XFILLER_82_423 VDD VDD VSS VSS gf180mcu_fd_sc_mcu7t5v0__fillcap_8
XFILLER_54_103 VDD VDD VSS VSS gf180mcu_fd_sc_mcu7t5v0__fill_2
X_2027_ _2027_/D _2033_/RN _2031_/CLK _2027_/Q VDD VDD VSS VSS gf180mcu_fd_sc_mcu7t5v0__dffrnq_1
XFILLER_63_692 VDD VDD VSS VSS gf180mcu_fd_sc_mcu7t5v0__fill_2
XFILLER_24_49 VDD VDD VSS VSS gf180mcu_fd_sc_mcu7t5v0__fill_1
XFILLER_40_26 VDD VDD VSS VSS gf180mcu_fd_sc_mcu7t5v0__fill_1
XFILLER_40_37 VDD VDD VSS VSS gf180mcu_fd_sc_mcu7t5v0__fillcap_16
XFILLER_2_405 VDD VDD VSS VSS gf180mcu_fd_sc_mcu7t5v0__fill_2
XTAP_TAPCELL_ROW_86_1026 VDD VSS gf180mcu_fd_sc_mcu7t5v0__filltie
XFILLER_65_67 VDD VDD VSS VSS gf180mcu_fd_sc_mcu7t5v0__fill_2
XFILLER_73_478 VDD VDD VSS VSS gf180mcu_fd_sc_mcu7t5v0__fillcap_8
XFILLER_26_383 VDD VDD VSS VSS gf180mcu_fd_sc_mcu7t5v0__fill_2
XFILLER_60_128 VDD VDD VSS VSS gf180mcu_fd_sc_mcu7t5v0__fillcap_4
XFILLER_14_589 VDD VDD VSS VSS gf180mcu_fd_sc_mcu7t5v0__fillcap_4
XFILLER_81_66 VDD VDD VSS VSS gf180mcu_fd_sc_mcu7t5v0__fillcap_4
XFILLER_81_88 VDD VDD VSS VSS gf180mcu_fd_sc_mcu7t5v0__fill_1
XTAP_TAPCELL_ROW_97_1133 VDD VSS gf180mcu_fd_sc_mcu7t5v0__filltie
X_1260_ _2161_/Q _2162_/Q _2163_/Q _2164_/Q _1260_/Z VDD VDD VSS VSS gf180mcu_fd_sc_mcu7t5v0__and4_1
Xinput8 cfg_data_i[11] input8/Z VDD VDD VSS VSS gf180mcu_fd_sc_mcu7t5v0__dlyb_1
X_1191_ _1191_/A1 _1971_/Q _1191_/A3 _1191_/A4 _1191_/Z VDD VDD VSS VSS gf180mcu_fd_sc_mcu7t5v0__and4_1
XFILLER_39_90 VDD VDD VSS VSS gf180mcu_fd_sc_mcu7t5v0__fillcap_16
Xclkbuf_5_27__f_sys_clk_i clkbuf_4_13_0_sys_clk_i/Z clkload6/I VDD VDD VSS VSS gf180mcu_fd_sc_mcu7t5v0__clkbuf_16
XFILLER_36_169 VDD VDD VSS VSS gf180mcu_fd_sc_mcu7t5v0__fillcap_4
XTAP_TAPCELL_ROW_19_389 VDD VSS gf180mcu_fd_sc_mcu7t5v0__filltie
XFILLER_51_139 VDD VDD VSS VSS gf180mcu_fd_sc_mcu7t5v0__fill_1
XFILLER_32_342 VDD VDD VSS VSS gf180mcu_fd_sc_mcu7t5v0__fill_2
X_0975_ _0906_/I _1673_/A3 _1604_/A4 _1648_/A1 VDD VDD VSS VSS gf180mcu_fd_sc_mcu7t5v0__nand3_1
X_1527_ _1477_/B _1527_/A2 _1527_/B _1927_/D VDD VDD VSS VSS gf180mcu_fd_sc_mcu7t5v0__oai21_1
XFILLER_19_16 VDD VDD VSS VSS gf180mcu_fd_sc_mcu7t5v0__fill_1
X_1458_ _1940_/Q _1948_/Q _1472_/S _1458_/Z VDD VDD VSS VSS gf180mcu_fd_sc_mcu7t5v0__mux2_2
XFILLER_87_559 VDD VDD VSS VSS gf180mcu_fd_sc_mcu7t5v0__fill_1
X_1389_ _2103_/D _1179_/Z _1393_/B1 input66/Z _1391_/A1 VDD VDD VSS VSS gf180mcu_fd_sc_mcu7t5v0__aoi22_1
XTAP_TAPCELL_ROW_2_235 VDD VSS gf180mcu_fd_sc_mcu7t5v0__filltie
XFILLER_55_489 VDD VDD VSS VSS gf180mcu_fd_sc_mcu7t5v0__fill_1
XFILLER_11_504 VDD VDD VSS VSS gf180mcu_fd_sc_mcu7t5v0__fill_1
Xwire406 wire406/I cfg_rx_size_o[15] VDD VDD VSS VSS gf180mcu_fd_sc_mcu7t5v0__clkbuf_3
XFILLER_11_559 VDD VDD VSS VSS gf180mcu_fd_sc_mcu7t5v0__fill_1
XTAP_TAPCELL_ROW_92_1085 VDD VSS gf180mcu_fd_sc_mcu7t5v0__filltie
XFILLER_78_504 VDD VDD VSS VSS gf180mcu_fd_sc_mcu7t5v0__fillcap_16
XFILLER_78_559 VDD VDD VSS VSS gf180mcu_fd_sc_mcu7t5v0__fillcap_8
XFILLER_19_648 VDD VDD VSS VSS gf180mcu_fd_sc_mcu7t5v0__fillcap_8
XFILLER_86_592 VDD VDD VSS VSS gf180mcu_fd_sc_mcu7t5v0__fill_2
XFILLER_73_220 VDD VDD VSS VSS gf180mcu_fd_sc_mcu7t5v0__fillcap_4
XTAP_TAPCELL_ROW_72_900 VDD VSS gf180mcu_fd_sc_mcu7t5v0__filltie
XFILLER_46_489 VDD VDD VSS VSS gf180mcu_fd_sc_mcu7t5v0__fillcap_4
XFILLER_33_139 VDD VDD VSS VSS gf180mcu_fd_sc_mcu7t5v0__fill_1
XTAP_TAPCELL_ROW_44_635 VDD VSS gf180mcu_fd_sc_mcu7t5v0__filltie
X_1312_ _1887_/Q _1879_/Q _1871_/Q _1863_/Q _1312_/S0 _1312_/S1 _1312_/Z VDD VDD VSS
+ VSS gf180mcu_fd_sc_mcu7t5v0__mux4_1
XFILLER_69_559 VDD VDD VSS VSS gf180mcu_fd_sc_mcu7t5v0__fill_1
X_1243_ _2142_/Q _2143_/Q _2144_/Q _1243_/A4 _1243_/Z VDD VDD VSS VSS gf180mcu_fd_sc_mcu7t5v0__and4_1
XFILLER_2_85 VDD VDD VSS VSS gf180mcu_fd_sc_mcu7t5v0__fill_1
X_1174_ _1319_/B _1319_/C _1338_/A2 VDD VDD VSS VSS gf180mcu_fd_sc_mcu7t5v0__nand2_1
XFILLER_20_312 VDD VDD VSS VSS gf180mcu_fd_sc_mcu7t5v0__fill_2
XFILLER_20_323 VDD VDD VSS VSS gf180mcu_fd_sc_mcu7t5v0__fill_1
XFILLER_32_161 VDD VDD VSS VSS gf180mcu_fd_sc_mcu7t5v0__fillcap_8
XFILLER_20_334 VDD VDD VSS VSS gf180mcu_fd_sc_mcu7t5v0__fillcap_32
X_0958_ _2081_/Q _1739_/B VDD VDD VSS VSS gf180mcu_fd_sc_mcu7t5v0__clkinv_1
Xoutput142 _1385_/ZN wire240/I VDD VDD VSS VSS gf180mcu_fd_sc_mcu7t5v0__buf_1
Xoutput131 _1190_/Z wire299/I VDD VDD VSS VSS gf180mcu_fd_sc_mcu7t5v0__buf_1
Xoutput120 _1180_/Z wire309/I VDD VDD VSS VSS gf180mcu_fd_sc_mcu7t5v0__buf_1
Xoutput186 _2020_/Q wire374/I VDD VDD VSS VSS gf180mcu_fd_sc_mcu7t5v0__buf_1
Xoutput175 _1987_/Q wire385/I VDD VDD VSS VSS gf180mcu_fd_sc_mcu7t5v0__buf_1
Xoutput164 _1978_/Q wire396/I VDD VDD VSS VSS gf180mcu_fd_sc_mcu7t5v0__buf_1
Xoutput153 _2004_/Q wire407/I VDD VDD VSS VSS gf180mcu_fd_sc_mcu7t5v0__buf_1
Xoutput197 _2018_/Q wire363/I VDD VDD VSS VSS gf180mcu_fd_sc_mcu7t5v0__buf_1
XFILLER_68_592 VDD VDD VSS VSS gf180mcu_fd_sc_mcu7t5v0__fill_2
XFILLER_28_489 VDD VDD VSS VSS gf180mcu_fd_sc_mcu7t5v0__fill_2
XFILLER_83_562 VDD VDD VSS VSS gf180mcu_fd_sc_mcu7t5v0__fillcap_16
XFILLER_46_69 VDD VDD VSS VSS gf180mcu_fd_sc_mcu7t5v0__fillcap_16
XFILLER_15_139 VDD VDD VSS VSS gf180mcu_fd_sc_mcu7t5v0__fill_1
XFILLER_70_223 VDD VDD VSS VSS gf180mcu_fd_sc_mcu7t5v0__fillcap_16
XTAP_TAPCELL_ROW_41_605 VDD VSS gf180mcu_fd_sc_mcu7t5v0__filltie
XFILLER_23_150 VDD VDD VSS VSS gf180mcu_fd_sc_mcu7t5v0__fillcap_4
XFILLER_51_492 VDD VDD VSS VSS gf180mcu_fd_sc_mcu7t5v0__fill_2
Xwire247 wire247/I cfg_data_o[11] VDD VDD VSS VSS gf180mcu_fd_sc_mcu7t5v0__clkbuf_3
Xwire236 wire236/I uart_tx_o VDD VDD VSS VSS gf180mcu_fd_sc_mcu7t5v0__clkbuf_3
Xwire225 wire225/I cfg_data_o[4] VDD VDD VSS VSS gf180mcu_fd_sc_mcu7t5v0__clkbuf_3
Xwire258 wire258/I data_tx_req_o VDD VDD VSS VSS gf180mcu_fd_sc_mcu7t5v0__clkbuf_3
XTAP_TAPCELL_ROW_94_1103 VDD VSS gf180mcu_fd_sc_mcu7t5v0__filltie
XFILLER_11_72 VDD VDD VSS VSS gf180mcu_fd_sc_mcu7t5v0__fillcap_32
XFILLER_78_367 VDD VDD VSS VSS gf180mcu_fd_sc_mcu7t5v0__fillcap_16
XFILLER_19_445 VDD VDD VSS VSS gf180mcu_fd_sc_mcu7t5v0__fillcap_4
XFILLER_19_489 VDD VDD VSS VSS gf180mcu_fd_sc_mcu7t5v0__fill_1
Xclkbuf_4_10_0_sys_clk_i clkbuf_0_sys_clk_i/Z clkbuf_4_10_0_sys_clk_i/Z VDD VDD VSS
+ VSS gf180mcu_fd_sc_mcu7t5v0__clkbuf_2
XTAP_TAPCELL_ROW_29_484 VDD VSS gf180mcu_fd_sc_mcu7t5v0__filltie
XFILLER_61_212 VDD VDD VSS VSS gf180mcu_fd_sc_mcu7t5v0__fillcap_16
X_1930_ _1930_/D _1948_/RN clkload4/I _2124_/D VDD VDD VSS VSS gf180mcu_fd_sc_mcu7t5v0__dffsnq_1
XFILLER_30_654 VDD VDD VSS VSS gf180mcu_fd_sc_mcu7t5v0__fill_2
X_1861_ _1861_/D _2156_/RN _2182_/CLK _1861_/Q VDD VDD VSS VSS gf180mcu_fd_sc_mcu7t5v0__dffrnq_1
Xinput11 cfg_data_i[14] input11/Z VDD VDD VSS VSS gf180mcu_fd_sc_mcu7t5v0__dlyb_1
Xinput22 cfg_data_i[24] input22/Z VDD VDD VSS VSS gf180mcu_fd_sc_mcu7t5v0__dlyb_1
X_1792_ _1822_/B _1792_/A2 _1793_/A2 VDD VDD VSS VSS gf180mcu_fd_sc_mcu7t5v0__nand2_1
Xinput33 cfg_data_i[5] input33/Z VDD VDD VSS VSS gf180mcu_fd_sc_mcu7t5v0__dlyb_1
Xinput44 cfg_rx_bytes_left_i[14] input44/Z VDD VDD VSS VSS gf180mcu_fd_sc_mcu7t5v0__dlyb_1
Xinput55 cfg_rx_curr_addr_i[0] input55/Z VDD VDD VSS VSS gf180mcu_fd_sc_mcu7t5v0__dlyb_1
Xmax_cap536 _1847_/S _1853_/S VDD VDD VSS VSS gf180mcu_fd_sc_mcu7t5v0__buf_2
Xinput88 cfg_tx_curr_addr_i[1] input88/Z VDD VDD VSS VSS gf180mcu_fd_sc_mcu7t5v0__dlyb_1
Xinput77 cfg_tx_bytes_left_i[2] input77/Z VDD VDD VSS VSS gf180mcu_fd_sc_mcu7t5v0__dlyb_1
Xinput66 cfg_rx_curr_addr_i[9] input66/Z VDD VDD VSS VSS gf180mcu_fd_sc_mcu7t5v0__dlyb_1
Xmax_cap558 _2018_/RN _2034_/RN VDD VDD VSS VSS gf180mcu_fd_sc_mcu7t5v0__buf_2
Xmax_cap547 _2126_/RN _1957_/RN VDD VDD VSS VSS gf180mcu_fd_sc_mcu7t5v0__buf_2
Xinput99 cfg_valid_i _1319_/C VDD VDD VSS VSS gf180mcu_fd_sc_mcu7t5v0__dlyb_1
XFILLER_69_301 VDD VDD VSS VSS gf180mcu_fd_sc_mcu7t5v0__fillcap_32
XFILLER_97_632 VDD VDD VSS VSS gf180mcu_fd_sc_mcu7t5v0__fillcap_8
X_1226_ _2138_/Q _2139_/Q _1211_/Z _1217_/Z _1226_/Z VDD VDD VSS VSS gf180mcu_fd_sc_mcu7t5v0__and4_1
XFILLER_25_404 VDD VDD VSS VSS gf180mcu_fd_sc_mcu7t5v0__fillcap_4
X_1157_ _1157_/A1 _1114_/Z _1119_/Z _1157_/B2 _1157_/C1 _1124_/Z _1158_/A3 VDD VDD
+ VSS VSS gf180mcu_fd_sc_mcu7t5v0__oai222_1
XFILLER_80_510 VDD VDD VSS VSS gf180mcu_fd_sc_mcu7t5v0__fillcap_8
XFILLER_65_562 VDD VDD VSS VSS gf180mcu_fd_sc_mcu7t5v0__fillcap_4
XFILLER_52_234 VDD VDD VSS VSS gf180mcu_fd_sc_mcu7t5v0__fillcap_8
X_1088_ _2094_/Q _2170_/Q _1091_/A2 VDD VDD VSS VSS gf180mcu_fd_sc_mcu7t5v0__nand2_1
XFILLER_80_554 VDD VDD VSS VSS gf180mcu_fd_sc_mcu7t5v0__fillcap_8
XFILLER_33_492 VDD VDD VSS VSS gf180mcu_fd_sc_mcu7t5v0__fillcap_16
XFILLER_87_142 VDD VDD VSS VSS gf180mcu_fd_sc_mcu7t5v0__fillcap_64
XFILLER_75_337 VDD VDD VSS VSS gf180mcu_fd_sc_mcu7t5v0__fillcap_8
XTAP_TAPCELL_ROW_54_730 VDD VSS gf180mcu_fd_sc_mcu7t5v0__filltie
XFILLER_43_212 VDD VDD VSS VSS gf180mcu_fd_sc_mcu7t5v0__fillcap_16
XFILLER_71_554 VDD VDD VSS VSS gf180mcu_fd_sc_mcu7t5v0__fill_1
XFILLER_7_124 VDD VDD VSS VSS gf180mcu_fd_sc_mcu7t5v0__fill_1
XFILLER_3_352 VDD VDD VSS VSS gf180mcu_fd_sc_mcu7t5v0__fill_2
X_2060_ _2060_/D _2161_/RN _2063_/CLK _2060_/Q VDD VDD VSS VSS gf180mcu_fd_sc_mcu7t5v0__dffsnq_1
X_1011_ _1932_/Q _1933_/Q _1934_/Q _1935_/Q _1820_/A2 VDD VDD VSS VSS gf180mcu_fd_sc_mcu7t5v0__aoi22_1
XFILLER_47_562 VDD VDD VSS VSS gf180mcu_fd_sc_mcu7t5v0__fillcap_4
XFILLER_19_275 VDD VDD VSS VSS gf180mcu_fd_sc_mcu7t5v0__fillcap_4
XFILLER_22_429 VDD VDD VSS VSS gf180mcu_fd_sc_mcu7t5v0__fill_1
X_1913_ _1913_/D _1951_/RN _1954_/CLK _1913_/Q VDD VDD VSS VSS gf180mcu_fd_sc_mcu7t5v0__dffrnq_1
X_1844_ _1966_/Q _2091_/Q _1848_/S _2091_/D VDD VDD VSS VSS gf180mcu_fd_sc_mcu7t5v0__mux2_2
X_1775_ _1821_/A2 _1905_/Q _1897_/Q _1789_/A2 _1799_/C _1777_/A1 VDD VDD VSS VSS gf180mcu_fd_sc_mcu7t5v0__aoi221_1
XFILLER_89_418 VDD VDD VSS VSS gf180mcu_fd_sc_mcu7t5v0__fill_2
XFILLER_69_142 VDD VDD VSS VSS gf180mcu_fd_sc_mcu7t5v0__fillcap_32
XFILLER_84_101 VDD VDD VSS VSS gf180mcu_fd_sc_mcu7t5v0__fillcap_4
XFILLER_27_16 VDD VDD VSS VSS gf180mcu_fd_sc_mcu7t5v0__fill_1
XTAP_TAPCELL_ROW_68_855 VDD VSS gf180mcu_fd_sc_mcu7t5v0__filltie
X_1209_ _1247_/A1 _1209_/A2 _1208_/Z _2134_/D VDD VDD VSS VSS gf180mcu_fd_sc_mcu7t5v0__nor3_1
XFILLER_25_201 VDD VDD VSS VSS gf180mcu_fd_sc_mcu7t5v0__fillcap_8
XFILLER_25_212 VDD VDD VSS VSS gf180mcu_fd_sc_mcu7t5v0__fillcap_4
X_2189_ _2191_/Q _2193_/RN _2189_/CLK _2193_/D VDD VDD VSS VSS gf180mcu_fd_sc_mcu7t5v0__dffrnq_1
XFILLER_25_234 VDD VDD VSS VSS gf180mcu_fd_sc_mcu7t5v0__fillcap_16
XTAP_TAPCELL_ROW_51_700 VDD VSS gf180mcu_fd_sc_mcu7t5v0__filltie
XFILLER_80_384 VDD VDD VSS VSS gf180mcu_fd_sc_mcu7t5v0__fill_1
XFILLER_21_440 VDD VDD VSS VSS gf180mcu_fd_sc_mcu7t5v0__fillcap_8
XTAP_TAPCELL_ROW_23_435 VDD VSS gf180mcu_fd_sc_mcu7t5v0__filltie
XPHY_EDGE_ROW_80_Left_179 VDD VSS gf180mcu_fd_sc_mcu7t5v0__endcap
XFILLER_5_628 VDD VDD VSS VSS gf180mcu_fd_sc_mcu7t5v0__fill_2
XFILLER_68_34 VDD VDD VSS VSS gf180mcu_fd_sc_mcu7t5v0__fill_1
XFILLER_75_112 VDD VDD VSS VSS gf180mcu_fd_sc_mcu7t5v0__fill_2
XFILLER_75_123 VDD VDD VSS VSS gf180mcu_fd_sc_mcu7t5v0__fillcap_16
XTAP_TAPCELL_ROW_89_1057 VDD VSS gf180mcu_fd_sc_mcu7t5v0__filltie
XFILLER_44_521 VDD VDD VSS VSS gf180mcu_fd_sc_mcu7t5v0__fillcap_4
XFILLER_71_340 VDD VDD VSS VSS gf180mcu_fd_sc_mcu7t5v0__fillcap_8
XFILLER_71_362 VDD VDD VSS VSS gf180mcu_fd_sc_mcu7t5v0__fill_1
XFILLER_12_473 VDD VDD VSS VSS gf180mcu_fd_sc_mcu7t5v0__fillcap_8
XFILLER_33_92 VDD VDD VSS VSS gf180mcu_fd_sc_mcu7t5v0__fill_2
XFILLER_76_8 VDD VDD VSS VSS gf180mcu_fd_sc_mcu7t5v0__fillcap_8
X_1560_ _1939_/Q _1577_/A1 _1939_/D VDD VDD VSS VSS gf180mcu_fd_sc_mcu7t5v0__xor2_1
XFILLER_4_661 VDD VDD VSS VSS gf180mcu_fd_sc_mcu7t5v0__fillcap_4
X_1491_ _1497_/A1 _1521_/A2 _1491_/B _1908_/D VDD VDD VSS VSS gf180mcu_fd_sc_mcu7t5v0__oai21_1
XFILLER_4_683 VDD VDD VSS VSS gf180mcu_fd_sc_mcu7t5v0__fillcap_4
X_2112_ _2112_/D _2185_/RN _2189_/CLK _2112_/Q VDD VDD VSS VSS gf180mcu_fd_sc_mcu7t5v0__dffrnq_1
X_2043_ _2043_/D _0904_/I clkload2/I _2043_/Q VDD VDD VSS VSS gf180mcu_fd_sc_mcu7t5v0__dffrnq_1
XFILLER_90_693 VDD VDD VSS VSS gf180mcu_fd_sc_mcu7t5v0__fill_1
XFILLER_62_384 VDD VDD VSS VSS gf180mcu_fd_sc_mcu7t5v0__fill_1
XFILLER_50_524 VDD VDD VSS VSS gf180mcu_fd_sc_mcu7t5v0__fill_1
XTAP_TAPCELL_ROW_20_405 VDD VSS gf180mcu_fd_sc_mcu7t5v0__filltie
X_1827_ _1829_/A2 _1829_/A3 _2079_/Q _1832_/A2 _1828_/A2 VDD VDD VSS VSS gf180mcu_fd_sc_mcu7t5v0__nand4_1
X_1758_ _1758_/A1 _1753_/C _2070_/D VDD VDD VSS VSS gf180mcu_fd_sc_mcu7t5v0__nor2_1
X_1689_ _1687_/Z _1688_/Z _2052_/Q _1690_/A2 VDD VDD VSS VSS gf180mcu_fd_sc_mcu7t5v0__aoi21_1
XFILLER_38_37 VDD VDD VSS VSS gf180mcu_fd_sc_mcu7t5v0__fillcap_8
XFILLER_73_627 VDD VDD VSS VSS gf180mcu_fd_sc_mcu7t5v0__fill_2
XFILLER_72_104 VDD VDD VSS VSS gf180mcu_fd_sc_mcu7t5v0__fill_1
XFILLER_79_88 VDD VDD VSS VSS gf180mcu_fd_sc_mcu7t5v0__fillcap_8
XFILLER_1_664 VDD VDD VSS VSS gf180mcu_fd_sc_mcu7t5v0__fillcap_16
XTAP_TAPCELL_ROW_8_285 VDD VSS gf180mcu_fd_sc_mcu7t5v0__filltie
XFILLER_48_167 VDD VDD VSS VSS gf180mcu_fd_sc_mcu7t5v0__fill_2
XFILLER_63_137 VDD VDD VSS VSS gf180mcu_fd_sc_mcu7t5v0__fill_2
XFILLER_63_104 VDD VDD VSS VSS gf180mcu_fd_sc_mcu7t5v0__fillcap_16
XTAP_TAPCELL_ROW_62_806 VDD VSS gf180mcu_fd_sc_mcu7t5v0__filltie
XFILLER_72_693 VDD VDD VSS VSS gf180mcu_fd_sc_mcu7t5v0__fill_1
XFILLER_71_181 VDD VDD VSS VSS gf180mcu_fd_sc_mcu7t5v0__fillcap_16
XFILLER_44_395 VDD VDD VSS VSS gf180mcu_fd_sc_mcu7t5v0__fill_1
X_0991_ _0991_/A1 _0991_/A2 _0991_/A3 _0990_/Z _1449_/B VDD VDD VSS VSS gf180mcu_fd_sc_mcu7t5v0__nand4_1
X_1612_ input35/Z _1985_/Q _1616_/S _1985_/D VDD VDD VSS VSS gf180mcu_fd_sc_mcu7t5v0__mux2_2
X_1543_ _1932_/Q _1933_/Q _1545_/S _1933_/D VDD VDD VSS VSS gf180mcu_fd_sc_mcu7t5v0__mux2_2
X_1474_ _2124_/D _2125_/D _1474_/B _1474_/C _1477_/B VDD VDD VSS VSS gf180mcu_fd_sc_mcu7t5v0__aoi211_1
XTAP_TAPCELL_ROW_78_950 VDD VSS gf180mcu_fd_sc_mcu7t5v0__filltie
XFILLER_39_178 VDD VDD VSS VSS gf180mcu_fd_sc_mcu7t5v0__fillcap_32
X_2026_ _2026_/D _2034_/RN _2034_/CLK _2026_/Q VDD VDD VSS VSS gf180mcu_fd_sc_mcu7t5v0__dffrnq_1
XFILLER_82_479 VDD VDD VSS VSS gf180mcu_fd_sc_mcu7t5v0__fillcap_4
XFILLER_82_457 VDD VDD VSS VSS gf180mcu_fd_sc_mcu7t5v0__fillcap_4
XFILLER_54_148 VDD VDD VSS VSS gf180mcu_fd_sc_mcu7t5v0__fillcap_16
XFILLER_23_513 VDD VDD VSS VSS gf180mcu_fd_sc_mcu7t5v0__fill_1
XTAP_TAPCELL_ROW_33_530 VDD VSS gf180mcu_fd_sc_mcu7t5v0__filltie
XFILLER_23_568 VDD VDD VSS VSS gf180mcu_fd_sc_mcu7t5v0__fill_1
XFILLER_50_387 VDD VDD VSS VSS gf180mcu_fd_sc_mcu7t5v0__fillcap_16
XFILLER_77_207 VDD VDD VSS VSS gf180mcu_fd_sc_mcu7t5v0__fill_2
XFILLER_49_69 VDD VDD VSS VSS gf180mcu_fd_sc_mcu7t5v0__fill_1
XFILLER_58_454 VDD VDD VSS VSS gf180mcu_fd_sc_mcu7t5v0__fill_1
XTAP_TAPCELL_ROW_86_1027 VDD VSS gf180mcu_fd_sc_mcu7t5v0__filltie
XFILLER_54_693 VDD VDD VSS VSS gf180mcu_fd_sc_mcu7t5v0__fill_1
XFILLER_41_343 VDD VDD VSS VSS gf180mcu_fd_sc_mcu7t5v0__fillcap_4
XTAP_TAPCELL_ROW_97_1134 VDD VSS gf180mcu_fd_sc_mcu7t5v0__filltie
XFILLER_5_277 VDD VDD VSS VSS gf180mcu_fd_sc_mcu7t5v0__fill_2
XFILLER_96_527 VDD VDD VSS VSS gf180mcu_fd_sc_mcu7t5v0__fillcap_64
XFILLER_1_483 VDD VDD VSS VSS gf180mcu_fd_sc_mcu7t5v0__fillcap_4
X_1190_ _1195_/A1 _1970_/Q _1195_/A3 _1191_/A4 _1190_/Z VDD VDD VSS VSS gf180mcu_fd_sc_mcu7t5v0__and4_1
Xinput9 cfg_data_i[12] input9/Z VDD VDD VSS VSS gf180mcu_fd_sc_mcu7t5v0__dlyb_1
XTAP_TAPCELL_ROW_47_655 VDD VSS gf180mcu_fd_sc_mcu7t5v0__filltie
XFILLER_64_457 VDD VDD VSS VSS gf180mcu_fd_sc_mcu7t5v0__fillcap_16
XFILLER_64_446 VDD VDD VSS VSS gf180mcu_fd_sc_mcu7t5v0__fillcap_8
XFILLER_91_276 VDD VDD VSS VSS gf180mcu_fd_sc_mcu7t5v0__fillcap_4
XFILLER_17_384 VDD VDD VSS VSS gf180mcu_fd_sc_mcu7t5v0__fillcap_8
XFILLER_20_527 VDD VDD VSS VSS gf180mcu_fd_sc_mcu7t5v0__fillcap_4
XTAP_TAPCELL_ROW_30_500 VDD VSS gf180mcu_fd_sc_mcu7t5v0__filltie
X_0974_ _0982_/A1 _1604_/A3 _0907_/I _1319_/B _0978_/A4 VDD VDD VSS VSS gf180mcu_fd_sc_mcu7t5v0__nor4_1
X_1526_ _1526_/A1 _1927_/Q _1527_/B VDD VDD VSS VSS gf180mcu_fd_sc_mcu7t5v0__nand2_1
XFILLER_59_207 VDD VDD VSS VSS gf180mcu_fd_sc_mcu7t5v0__fill_2
X_1457_ _1577_/A1 _1501_/A3 _1478_/A1 _1473_/S VDD VDD VSS VSS gf180mcu_fd_sc_mcu7t5v0__nand3_4
XFILLER_28_605 VDD VDD VSS VSS gf180mcu_fd_sc_mcu7t5v0__fillcap_4
X_1388_ _1388_/A1 _1388_/A2 _1388_/ZN VDD VDD VSS VSS gf180mcu_fd_sc_mcu7t5v0__nand2_1
XTAP_TAPCELL_ROW_2_236 VDD VSS gf180mcu_fd_sc_mcu7t5v0__filltie
XFILLER_35_38 VDD VDD VSS VSS gf180mcu_fd_sc_mcu7t5v0__fill_1
XFILLER_42_107 VDD VDD VSS VSS gf180mcu_fd_sc_mcu7t5v0__fillcap_64
X_2009_ _2009_/D _2020_/RN _2021_/CLK _2009_/Q VDD VDD VSS VSS gf180mcu_fd_sc_mcu7t5v0__dffrnq_1
XFILLER_82_298 VDD VDD VSS VSS gf180mcu_fd_sc_mcu7t5v0__fillcap_16
XTAP_TAPCELL_ROW_81_978 VDD VSS gf180mcu_fd_sc_mcu7t5v0__filltie
XFILLER_51_674 VDD VDD VSS VSS gf180mcu_fd_sc_mcu7t5v0__fill_1
Xwire407 wire407/I cfg_rx_size_o[14] VDD VDD VSS VSS gf180mcu_fd_sc_mcu7t5v0__clkbuf_3
XTAP_TAPCELL_ROW_92_1086 VDD VSS gf180mcu_fd_sc_mcu7t5v0__filltie
XFILLER_78_527 VDD VDD VSS VSS gf180mcu_fd_sc_mcu7t5v0__fillcap_32
XFILLER_76_34 VDD VDD VSS VSS gf180mcu_fd_sc_mcu7t5v0__fill_1
XFILLER_19_605 VDD VDD VSS VSS gf180mcu_fd_sc_mcu7t5v0__fillcap_8
XFILLER_58_251 VDD VDD VSS VSS gf180mcu_fd_sc_mcu7t5v0__fill_2
XFILLER_76_78 VDD VDD VSS VSS gf180mcu_fd_sc_mcu7t5v0__fillcap_8
XFILLER_18_159 VDD VDD VSS VSS gf180mcu_fd_sc_mcu7t5v0__fill_1
XFILLER_73_232 VDD VDD VSS VSS gf180mcu_fd_sc_mcu7t5v0__fillcap_4
XFILLER_46_457 VDD VDD VSS VSS gf180mcu_fd_sc_mcu7t5v0__fillcap_32
XTAP_TAPCELL_ROW_72_901 VDD VSS gf180mcu_fd_sc_mcu7t5v0__filltie
XFILLER_25_60 VDD VDD VSS VSS gf180mcu_fd_sc_mcu7t5v0__fillcap_8
XFILLER_14_387 VDD VDD VSS VSS gf180mcu_fd_sc_mcu7t5v0__fillcap_32
XFILLER_6_531 VDD VDD VSS VSS gf180mcu_fd_sc_mcu7t5v0__fill_2
XFILLER_6_575 VDD VDD VSS VSS gf180mcu_fd_sc_mcu7t5v0__fill_1
X_1311_ _1886_/Q _1878_/Q _1870_/Q _1862_/Q _1311_/S0 _1311_/S1 _1311_/Z VDD VDD VSS
+ VSS gf180mcu_fd_sc_mcu7t5v0__mux4_1
X_1242_ _2144_/Q _1242_/A2 _1244_/A2 VDD VDD VSS VSS gf180mcu_fd_sc_mcu7t5v0__nor2_1
XPHY_EDGE_ROW_10_Right_10 VDD VSS gf180mcu_fd_sc_mcu7t5v0__endcap
XFILLER_37_424 VDD VDD VSS VSS gf180mcu_fd_sc_mcu7t5v0__fill_1
X_1173_ _1319_/B _1319_/C _1173_/Z VDD VDD VSS VSS gf180mcu_fd_sc_mcu7t5v0__and2_1
XFILLER_24_107 VDD VDD VSS VSS gf180mcu_fd_sc_mcu7t5v0__fillcap_64
XFILLER_25_619 VDD VDD VSS VSS gf180mcu_fd_sc_mcu7t5v0__fill_1
XFILLER_52_449 VDD VDD VSS VSS gf180mcu_fd_sc_mcu7t5v0__fill_1
XFILLER_32_173 VDD VDD VSS VSS gf180mcu_fd_sc_mcu7t5v0__fill_2
X_0957_ _2080_/Q _1830_/A2 VDD VDD VSS VSS gf180mcu_fd_sc_mcu7t5v0__clkinv_1
Xoutput143 _1388_/ZN wire239/I VDD VDD VSS VSS gf180mcu_fd_sc_mcu7t5v0__buf_1
Xoutput132 _1191_/Z wire298/I VDD VDD VSS VSS gf180mcu_fd_sc_mcu7t5v0__buf_1
Xoutput121 _1181_/Z wire308/I VDD VDD VSS VSS gf180mcu_fd_sc_mcu7t5v0__buf_1
Xoutput176 _2113_/Q wire384/I VDD VDD VSS VSS gf180mcu_fd_sc_mcu7t5v0__buf_1
Xoutput165 _1988_/Q wire395/I VDD VDD VSS VSS gf180mcu_fd_sc_mcu7t5v0__buf_1
Xoutput154 _2005_/Q wire406/I VDD VDD VSS VSS gf180mcu_fd_sc_mcu7t5v0__buf_1
X_1509_ _1472_/Z _1919_/Q _1509_/S _1919_/D VDD VDD VSS VSS gf180mcu_fd_sc_mcu7t5v0__mux2_2
Xoutput198 _2008_/Q wire362/I VDD VDD VSS VSS gf180mcu_fd_sc_mcu7t5v0__buf_1
Xoutput187 _2021_/Q wire373/I VDD VDD VSS VSS gf180mcu_fd_sc_mcu7t5v0__buf_1
XFILLER_75_519 VDD VDD VSS VSS gf180mcu_fd_sc_mcu7t5v0__fill_1
XFILLER_28_457 VDD VDD VSS VSS gf180mcu_fd_sc_mcu7t5v0__fillcap_32
XFILLER_46_37 VDD VDD VSS VSS gf180mcu_fd_sc_mcu7t5v0__fillcap_32
XFILLER_43_438 VDD VDD VSS VSS gf180mcu_fd_sc_mcu7t5v0__fill_1
XTAP_TAPCELL_ROW_41_606 VDD VSS gf180mcu_fd_sc_mcu7t5v0__filltie
Xwire248 wire248/I cfg_data_o[10] VDD VDD VSS VSS gf180mcu_fd_sc_mcu7t5v0__clkbuf_3
Xwire237 wire237/I err_event_o VDD VDD VSS VSS gf180mcu_fd_sc_mcu7t5v0__clkbuf_3
Xwire226 wire226/I cfg_data_o[3] VDD VDD VSS VSS gf180mcu_fd_sc_mcu7t5v0__clkbuf_3
XTAP_TAPCELL_ROW_94_1104 VDD VSS gf180mcu_fd_sc_mcu7t5v0__filltie
XFILLER_78_302 VDD VDD VSS VSS gf180mcu_fd_sc_mcu7t5v0__fillcap_8
XFILLER_87_66 VDD VDD VSS VSS gf180mcu_fd_sc_mcu7t5v0__fillcap_4
XTAP_TAPCELL_ROW_57_750 VDD VSS gf180mcu_fd_sc_mcu7t5v0__filltie
XFILLER_74_552 VDD VDD VSS VSS gf180mcu_fd_sc_mcu7t5v0__fillcap_8
XFILLER_34_427 VDD VDD VSS VSS gf180mcu_fd_sc_mcu7t5v0__fillcap_16
XTAP_TAPCELL_ROW_29_485 VDD VSS gf180mcu_fd_sc_mcu7t5v0__filltie
XFILLER_61_268 VDD VDD VSS VSS gf180mcu_fd_sc_mcu7t5v0__fill_1
XFILLER_61_279 VDD VDD VSS VSS gf180mcu_fd_sc_mcu7t5v0__fill_1
X_1860_ _1860_/D _1887_/RN _2063_/CLK _1860_/Q VDD VDD VSS VSS gf180mcu_fd_sc_mcu7t5v0__dffrnq_1
X_1791_ _1821_/A2 _1907_/Q _1899_/Q _1815_/B2 _1799_/C _1793_/A1 VDD VDD VSS VSS gf180mcu_fd_sc_mcu7t5v0__aoi221_1
Xinput12 cfg_data_i[15] input12/Z VDD VDD VSS VSS gf180mcu_fd_sc_mcu7t5v0__dlyb_1
XTAP_TAPCELL_ROW_12_330 VDD VSS gf180mcu_fd_sc_mcu7t5v0__filltie
Xinput23 cfg_data_i[25] input23/Z VDD VDD VSS VSS gf180mcu_fd_sc_mcu7t5v0__dlyb_1
Xinput34 cfg_data_i[6] input34/Z VDD VDD VSS VSS gf180mcu_fd_sc_mcu7t5v0__dlyb_1
Xinput45 cfg_rx_bytes_left_i[15] input45/Z VDD VDD VSS VSS gf180mcu_fd_sc_mcu7t5v0__dlyb_1
Xinput56 cfg_rx_curr_addr_i[10] input56/Z VDD VDD VSS VSS gf180mcu_fd_sc_mcu7t5v0__dlyb_1
Xinput89 cfg_tx_curr_addr_i[2] input89/Z VDD VDD VSS VSS gf180mcu_fd_sc_mcu7t5v0__dlyb_1
Xinput78 cfg_tx_bytes_left_i[3] input78/Z VDD VDD VSS VSS gf180mcu_fd_sc_mcu7t5v0__dlyb_1
Xinput67 cfg_rx_en_i input67/Z VDD VDD VSS VSS gf180mcu_fd_sc_mcu7t5v0__dlyb_1
Xmax_cap559 _2163_/RN _2174_/RN VDD VDD VSS VSS gf180mcu_fd_sc_mcu7t5v0__buf_2
Xmax_cap548 _2098_/RN _2097_/RN VDD VDD VSS VSS gf180mcu_fd_sc_mcu7t5v0__buf_2
Xmax_cap537 fanout310/Z _1849_/S VDD VDD VSS VSS gf180mcu_fd_sc_mcu7t5v0__buf_2
XFILLER_35_2 VDD VDD VSS VSS gf180mcu_fd_sc_mcu7t5v0__fill_2
XFILLER_97_644 VDD VDD VSS VSS gf180mcu_fd_sc_mcu7t5v0__fill_1
X_1225_ _2138_/Q _2139_/Q _1240_/A2 VDD VDD VSS VSS gf180mcu_fd_sc_mcu7t5v0__nand2_1
X_1156_ _1156_/A1 _2097_/Q _1156_/B _1158_/A2 VDD VDD VSS VSS gf180mcu_fd_sc_mcu7t5v0__oai21_1
XFILLER_65_574 VDD VDD VSS VSS gf180mcu_fd_sc_mcu7t5v0__fill_2
XFILLER_92_382 VDD VDD VSS VSS gf180mcu_fd_sc_mcu7t5v0__fill_2
XFILLER_80_544 VDD VDD VSS VSS gf180mcu_fd_sc_mcu7t5v0__fill_1
XFILLER_80_522 VDD VDD VSS VSS gf180mcu_fd_sc_mcu7t5v0__fill_2
X_1087_ _1138_/B1 _1281_/B _1091_/A1 VDD VDD VSS VSS gf180mcu_fd_sc_mcu7t5v0__nand2_1
XFILLER_33_471 VDD VDD VSS VSS gf180mcu_fd_sc_mcu7t5v0__fillcap_4
XFILLER_20_121 VDD VDD VSS VSS gf180mcu_fd_sc_mcu7t5v0__fill_1
X_1989_ _1989_/D _2034_/RN _2034_/CLK _1989_/Q VDD VDD VSS VSS gf180mcu_fd_sc_mcu7t5v0__dffrnq_1
XFILLER_57_14 VDD VDD VSS VSS gf180mcu_fd_sc_mcu7t5v0__fill_2
XFILLER_75_349 VDD VDD VSS VSS gf180mcu_fd_sc_mcu7t5v0__fill_1
XFILLER_90_308 VDD VDD VSS VSS gf180mcu_fd_sc_mcu7t5v0__fillcap_4
XFILLER_83_360 VDD VDD VSS VSS gf180mcu_fd_sc_mcu7t5v0__fillcap_4
XTAP_TAPCELL_ROW_26_455 VDD VSS gf180mcu_fd_sc_mcu7t5v0__filltie
XFILLER_71_544 VDD VDD VSS VSS gf180mcu_fd_sc_mcu7t5v0__fillcap_8
XFILLER_31_419 VDD VDD VSS VSS gf180mcu_fd_sc_mcu7t5v0__fill_1
XFILLER_43_279 VDD VDD VSS VSS gf180mcu_fd_sc_mcu7t5v0__fill_1
XFILLER_79_611 VDD VDD VSS VSS gf180mcu_fd_sc_mcu7t5v0__fill_2
XFILLER_79_666 VDD VDD VSS VSS gf180mcu_fd_sc_mcu7t5v0__fillcap_16
XFILLER_78_154 VDD VDD VSS VSS gf180mcu_fd_sc_mcu7t5v0__fill_1
XFILLER_66_305 VDD VDD VSS VSS gf180mcu_fd_sc_mcu7t5v0__fill_2
X_1010_ _1014_/A2 _1789_/A2 _1017_/A2 VDD VDD VSS VSS gf180mcu_fd_sc_mcu7t5v0__nand2_1
XFILLER_47_80 VDD VDD VSS VSS gf180mcu_fd_sc_mcu7t5v0__fillcap_4
XFILLER_22_419 VDD VDD VSS VSS gf180mcu_fd_sc_mcu7t5v0__fillcap_8
X_1912_ _1912_/D _1954_/RN _1954_/CLK _1912_/Q VDD VDD VSS VSS gf180mcu_fd_sc_mcu7t5v0__dffrnq_1
XTAP_TAPCELL_ROW_60_778 VDD VSS gf180mcu_fd_sc_mcu7t5v0__filltie
X_1843_ _1965_/Q _2090_/Q _1848_/S _2090_/D VDD VDD VSS VSS gf180mcu_fd_sc_mcu7t5v0__mux2_2
X_1774_ _1799_/C _1774_/A2 _1774_/A3 _1776_/A2 VDD VDD VSS VSS gf180mcu_fd_sc_mcu7t5v0__nand3_1
Xmax_cap345 _1475_/A3 _1478_/A1 VDD VDD VSS VSS gf180mcu_fd_sc_mcu7t5v0__clkbuf_2
XFILLER_85_625 VDD VDD VSS VSS gf180mcu_fd_sc_mcu7t5v0__fillcap_4
XTAP_TAPCELL_ROW_68_856 VDD VSS gf180mcu_fd_sc_mcu7t5v0__filltie
XFILLER_57_349 VDD VDD VSS VSS gf180mcu_fd_sc_mcu7t5v0__fill_1
X_1208_ _2132_/Q _2133_/Q _2134_/Q _1199_/Z _1208_/Z VDD VDD VSS VSS gf180mcu_fd_sc_mcu7t5v0__and4_1
X_2188_ _2188_/D _2188_/RN _2188_/CLK _2188_/Q VDD VDD VSS VSS gf180mcu_fd_sc_mcu7t5v0__dffrnq_1
XFILLER_93_680 VDD VDD VSS VSS gf180mcu_fd_sc_mcu7t5v0__fillcap_8
X_1139_ _1149_/A1 _1149_/A2 _1139_/A3 _1139_/A4 _1140_/A2 VDD VDD VSS VSS gf180mcu_fd_sc_mcu7t5v0__nand4_1
XFILLER_13_419 VDD VDD VSS VSS gf180mcu_fd_sc_mcu7t5v0__fill_1
XTAP_TAPCELL_ROW_51_701 VDD VSS gf180mcu_fd_sc_mcu7t5v0__filltie
XFILLER_21_452 VDD VDD VSS VSS gf180mcu_fd_sc_mcu7t5v0__fill_1
XFILLER_21_485 VDD VDD VSS VSS gf180mcu_fd_sc_mcu7t5v0__fillcap_4
XFILLER_88_452 VDD VDD VSS VSS gf180mcu_fd_sc_mcu7t5v0__fill_2
XTAP_TAPCELL_ROW_89_1058 VDD VSS gf180mcu_fd_sc_mcu7t5v0__filltie
XFILLER_84_34 VDD VDD VSS VSS gf180mcu_fd_sc_mcu7t5v0__fill_1
XFILLER_29_585 VDD VDD VSS VSS gf180mcu_fd_sc_mcu7t5v0__fill_2
XTAP_TAPCELL_ROW_39_580 VDD VSS gf180mcu_fd_sc_mcu7t5v0__filltie
XFILLER_84_691 VDD VDD VSS VSS gf180mcu_fd_sc_mcu7t5v0__fill_2
XFILLER_56_360 VDD VDD VSS VSS gf180mcu_fd_sc_mcu7t5v0__fillcap_16
XFILLER_17_72 VDD VDD VSS VSS gf180mcu_fd_sc_mcu7t5v0__fillcap_32
XFILLER_71_352 VDD VDD VSS VSS gf180mcu_fd_sc_mcu7t5v0__fillcap_8
X_1490_ _1511_/B _1466_/Z _1511_/C _1521_/A2 VDD VDD VSS VSS gf180mcu_fd_sc_mcu7t5v0__nand3_1
XFILLER_79_485 VDD VDD VSS VSS gf180mcu_fd_sc_mcu7t5v0__fillcap_4
X_2111_ _2111_/D _2111_/RN clkload6/I _2111_/Q VDD VDD VSS VSS gf180mcu_fd_sc_mcu7t5v0__dffrnq_1
XFILLER_79_496 VDD VDD VSS VSS gf180mcu_fd_sc_mcu7t5v0__fill_2
X_2042_ _2042_/D _2115_/RN _2191_/CLK _2042_/Q VDD VDD VSS VSS gf180mcu_fd_sc_mcu7t5v0__dffrnq_1
XFILLER_66_157 VDD VDD VSS VSS gf180mcu_fd_sc_mcu7t5v0__fill_2
XTAP_TAPCELL_ROW_65_826 VDD VSS gf180mcu_fd_sc_mcu7t5v0__filltie
XFILLER_75_680 VDD VDD VSS VSS gf180mcu_fd_sc_mcu7t5v0__fillcap_8
XPHY_EDGE_ROW_8_Right_8 VDD VSS gf180mcu_fd_sc_mcu7t5v0__endcap
XFILLER_90_683 VDD VDD VSS VSS gf180mcu_fd_sc_mcu7t5v0__fillcap_8
XFILLER_90_661 VDD VDD VSS VSS gf180mcu_fd_sc_mcu7t5v0__fillcap_4
XTAP_TAPCELL_ROW_20_406 VDD VSS gf180mcu_fd_sc_mcu7t5v0__filltie
X_1826_ _1826_/A1 _1826_/A2 _1826_/B _1828_/B VDD VDD VSS VSS gf180mcu_fd_sc_mcu7t5v0__aoi21_1
X_1757_ _1757_/A1 _1757_/A2 _1757_/B1 _2070_/Q _1758_/A1 VDD VDD VSS VSS gf180mcu_fd_sc_mcu7t5v0__aoi22_1
X_1688_ _1703_/B _2160_/Q _2053_/Q _1703_/C _1688_/Z VDD VDD VSS VSS gf180mcu_fd_sc_mcu7t5v0__and4_1
XPHY_EDGE_ROW_39_Right_39 VDD VSS gf180mcu_fd_sc_mcu7t5v0__endcap
XFILLER_85_422 VDD VDD VSS VSS gf180mcu_fd_sc_mcu7t5v0__fill_1
XFILLER_58_647 VDD VDD VSS VSS gf180mcu_fd_sc_mcu7t5v0__fillcap_16
XFILLER_66_691 VDD VDD VSS VSS gf180mcu_fd_sc_mcu7t5v0__fill_2
XFILLER_54_37 VDD VDD VSS VSS gf180mcu_fd_sc_mcu7t5v0__fillcap_16
XFILLER_53_330 VDD VDD VSS VSS gf180mcu_fd_sc_mcu7t5v0__fillcap_8
XFILLER_26_577 VDD VDD VSS VSS gf180mcu_fd_sc_mcu7t5v0__fillcap_16
XTAP_TAPCELL_ROW_36_550 VDD VSS gf180mcu_fd_sc_mcu7t5v0__filltie
XFILLER_53_352 VDD VDD VSS VSS gf180mcu_fd_sc_mcu7t5v0__fill_2
XPHY_EDGE_ROW_48_Right_48 VDD VSS gf180mcu_fd_sc_mcu7t5v0__endcap
XFILLER_41_558 VDD VDD VSS VSS gf180mcu_fd_sc_mcu7t5v0__fill_2
XFILLER_5_426 VDD VDD VSS VSS gf180mcu_fd_sc_mcu7t5v0__fill_2
XFILLER_79_45 VDD VDD VSS VSS gf180mcu_fd_sc_mcu7t5v0__fillcap_16
XPHY_EDGE_ROW_57_Right_57 VDD VSS gf180mcu_fd_sc_mcu7t5v0__endcap
XFILLER_1_632 VDD VDD VSS VSS gf180mcu_fd_sc_mcu7t5v0__fillcap_32
XTAP_TAPCELL_ROW_8_286 VDD VSS gf180mcu_fd_sc_mcu7t5v0__filltie
XFILLER_49_614 VDD VDD VSS VSS gf180mcu_fd_sc_mcu7t5v0__fill_1
XFILLER_95_66 VDD VDD VSS VSS gf180mcu_fd_sc_mcu7t5v0__fillcap_4
XFILLER_88_271 VDD VDD VSS VSS gf180mcu_fd_sc_mcu7t5v0__fill_2
XFILLER_49_658 VDD VDD VSS VSS gf180mcu_fd_sc_mcu7t5v0__fill_2
XFILLER_76_477 VDD VDD VSS VSS gf180mcu_fd_sc_mcu7t5v0__fill_2
XFILLER_29_360 VDD VDD VSS VSS gf180mcu_fd_sc_mcu7t5v0__fillcap_4
XFILLER_91_436 VDD VDD VSS VSS gf180mcu_fd_sc_mcu7t5v0__fill_2
XFILLER_76_488 VDD VDD VSS VSS gf180mcu_fd_sc_mcu7t5v0__fillcap_32
XFILLER_57_680 VDD VDD VSS VSS gf180mcu_fd_sc_mcu7t5v0__fillcap_8
XFILLER_17_588 VDD VDD VSS VSS gf180mcu_fd_sc_mcu7t5v0__fillcap_8
XFILLER_32_514 VDD VDD VSS VSS gf180mcu_fd_sc_mcu7t5v0__fill_2
XPHY_EDGE_ROW_66_Right_66 VDD VSS gf180mcu_fd_sc_mcu7t5v0__endcap
XFILLER_72_683 VDD VDD VSS VSS gf180mcu_fd_sc_mcu7t5v0__fillcap_8
XFILLER_71_171 VDD VDD VSS VSS gf180mcu_fd_sc_mcu7t5v0__fillcap_4
X_0990_ _0990_/A1 _1061_/A2 _2149_/Q _0990_/Z VDD VDD VSS VSS gf180mcu_fd_sc_mcu7t5v0__or3_1
XTAP_TAPCELL_ROW_70_873 VDD VSS gf180mcu_fd_sc_mcu7t5v0__filltie
XFILLER_8_264 VDD VDD VSS VSS gf180mcu_fd_sc_mcu7t5v0__fill_1
XFILLER_40_591 VDD VDD VSS VSS gf180mcu_fd_sc_mcu7t5v0__fillcap_4
X_1611_ input34/Z _1984_/Q _1611_/S _1984_/D VDD VDD VSS VSS gf180mcu_fd_sc_mcu7t5v0__mux2_2
XPHY_EDGE_ROW_75_Right_75 VDD VSS gf180mcu_fd_sc_mcu7t5v0__endcap
X_1542_ _1935_/Q _1932_/Q _1545_/S _1932_/D VDD VDD VSS VSS gf180mcu_fd_sc_mcu7t5v0__mux2_2
X_1473_ _1472_/Z _1903_/Q _1473_/S _1903_/D VDD VDD VSS VSS gf180mcu_fd_sc_mcu7t5v0__mux2_2
XFILLER_79_282 VDD VDD VSS VSS gf180mcu_fd_sc_mcu7t5v0__fillcap_8
XTAP_TAPCELL_ROW_78_951 VDD VSS gf180mcu_fd_sc_mcu7t5v0__filltie
XFILLER_94_241 VDD VDD VSS VSS gf180mcu_fd_sc_mcu7t5v0__fillcap_4
XFILLER_67_466 VDD VDD VSS VSS gf180mcu_fd_sc_mcu7t5v0__fillcap_4
XPHY_EDGE_ROW_84_Right_84 VDD VSS gf180mcu_fd_sc_mcu7t5v0__endcap
XFILLER_94_263 VDD VDD VSS VSS gf180mcu_fd_sc_mcu7t5v0__fillcap_8
XFILLER_54_116 VDD VDD VSS VSS gf180mcu_fd_sc_mcu7t5v0__fillcap_32
X_2025_ _2025_/D _2025_/RN _2025_/CLK _2025_/Q VDD VDD VSS VSS gf180mcu_fd_sc_mcu7t5v0__dffrnq_1
XFILLER_70_609 VDD VDD VSS VSS gf180mcu_fd_sc_mcu7t5v0__fill_1
XFILLER_35_352 VDD VDD VSS VSS gf180mcu_fd_sc_mcu7t5v0__fillcap_8
XFILLER_50_311 VDD VDD VSS VSS gf180mcu_fd_sc_mcu7t5v0__fillcap_4
XFILLER_23_558 VDD VDD VSS VSS gf180mcu_fd_sc_mcu7t5v0__fill_2
XPHY_EDGE_ROW_93_Right_93 VDD VSS gf180mcu_fd_sc_mcu7t5v0__endcap
X_1809_ _1809_/A1 _1809_/A2 _1809_/B _1809_/C _2076_/D VDD VDD VSS VSS gf180mcu_fd_sc_mcu7t5v0__oai211_1
XFILLER_98_580 VDD VDD VSS VSS gf180mcu_fd_sc_mcu7t5v0__fillcap_32
XTAP_TAPCELL_ROW_5_256 VDD VSS gf180mcu_fd_sc_mcu7t5v0__filltie
XFILLER_85_252 VDD VDD VSS VSS gf180mcu_fd_sc_mcu7t5v0__fillcap_16
XFILLER_73_403 VDD VDD VSS VSS gf180mcu_fd_sc_mcu7t5v0__fill_2
XFILLER_58_477 VDD VDD VSS VSS gf180mcu_fd_sc_mcu7t5v0__fillcap_32
XTAP_TAPCELL_ROW_86_1028 VDD VSS gf180mcu_fd_sc_mcu7t5v0__filltie
XFILLER_65_69 VDD VDD VSS VSS gf180mcu_fd_sc_mcu7t5v0__fill_1
XFILLER_45_138 VDD VDD VSS VSS gf180mcu_fd_sc_mcu7t5v0__fill_2
XFILLER_26_341 VDD VDD VSS VSS gf180mcu_fd_sc_mcu7t5v0__fillcap_4
XFILLER_54_683 VDD VDD VSS VSS gf180mcu_fd_sc_mcu7t5v0__fillcap_8
XFILLER_22_591 VDD VDD VSS VSS gf180mcu_fd_sc_mcu7t5v0__fillcap_4
XTAP_TAPCELL_ROW_97_1135 VDD VSS gf180mcu_fd_sc_mcu7t5v0__filltie
XFILLER_5_212 VDD VDD VSS VSS gf180mcu_fd_sc_mcu7t5v0__fill_2
XFILLER_49_422 VDD VDD VSS VSS gf180mcu_fd_sc_mcu7t5v0__fillcap_4
XFILLER_49_411 VDD VDD VSS VSS gf180mcu_fd_sc_mcu7t5v0__fillcap_4
XTAP_TAPCELL_ROW_75_921 VDD VSS gf180mcu_fd_sc_mcu7t5v0__filltie
XFILLER_76_263 VDD VDD VSS VSS gf180mcu_fd_sc_mcu7t5v0__fillcap_4
XTAP_TAPCELL_ROW_47_656 VDD VSS gf180mcu_fd_sc_mcu7t5v0__filltie
XFILLER_17_352 VDD VDD VSS VSS gf180mcu_fd_sc_mcu7t5v0__fillcap_32
XFILLER_32_311 VDD VDD VSS VSS gf180mcu_fd_sc_mcu7t5v0__fillcap_4
XFILLER_44_193 VDD VDD VSS VSS gf180mcu_fd_sc_mcu7t5v0__fill_2
XTAP_TAPCELL_ROW_30_501 VDD VSS gf180mcu_fd_sc_mcu7t5v0__filltie
X_0973_ input34/Z _0968_/Z _0973_/A3 _1673_/A3 _2115_/D VDD VDD VSS VSS gf180mcu_fd_sc_mcu7t5v0__and4_1
XFILLER_65_2 VDD VDD VSS VSS gf180mcu_fd_sc_mcu7t5v0__fillcap_4
X_1525_ _1525_/A1 _1525_/A2 _1525_/B _1926_/D VDD VDD VSS VSS gf180mcu_fd_sc_mcu7t5v0__oai21_1
X_1456_ _1956_/Q _1957_/Q _1456_/B _1580_/A2 VDD VDD VSS VSS gf180mcu_fd_sc_mcu7t5v0__oai21_1
X_1387_ input83/Z _1404_/A2 _1396_/A2 input53/Z _1392_/B1 input95/Z _1388_/A2 VDD
+ VDD VSS VSS gf180mcu_fd_sc_mcu7t5v0__aoi222_1
XFILLER_82_244 VDD VDD VSS VSS gf180mcu_fd_sc_mcu7t5v0__fill_1
XFILLER_82_277 VDD VDD VSS VSS gf180mcu_fd_sc_mcu7t5v0__fillcap_4
XFILLER_82_255 VDD VDD VSS VSS gf180mcu_fd_sc_mcu7t5v0__fillcap_4
XFILLER_23_322 VDD VDD VSS VSS gf180mcu_fd_sc_mcu7t5v0__fillcap_8
XFILLER_35_160 VDD VDD VSS VSS gf180mcu_fd_sc_mcu7t5v0__fill_1
X_2008_ _2008_/D _2117_/RN _2021_/CLK _2008_/Q VDD VDD VSS VSS gf180mcu_fd_sc_mcu7t5v0__dffrnq_1
XTAP_TAPCELL_ROW_81_979 VDD VSS gf180mcu_fd_sc_mcu7t5v0__filltie
XTAP_TAPCELL_ROW_18_380 VDD VSS gf180mcu_fd_sc_mcu7t5v0__filltie
XFILLER_51_664 VDD VDD VSS VSS gf180mcu_fd_sc_mcu7t5v0__fillcap_8
Xwire408 wire408/I cfg_rx_size_o[13] VDD VDD VSS VSS gf180mcu_fd_sc_mcu7t5v0__clkbuf_3
XTAP_TAPCELL_ROW_92_1087 VDD VSS gf180mcu_fd_sc_mcu7t5v0__filltie
XFILLER_86_594 VDD VDD VSS VSS gf180mcu_fd_sc_mcu7t5v0__fill_1
XFILLER_92_34 VDD VDD VSS VSS gf180mcu_fd_sc_mcu7t5v0__fill_1
XFILLER_61_417 VDD VDD VSS VSS gf180mcu_fd_sc_mcu7t5v0__fill_2
XFILLER_26_171 VDD VDD VSS VSS gf180mcu_fd_sc_mcu7t5v0__fillcap_4
XTAP_TAPCELL_ROW_44_626 VDD VSS gf180mcu_fd_sc_mcu7t5v0__filltie
XFILLER_14_333 VDD VDD VSS VSS gf180mcu_fd_sc_mcu7t5v0__fillcap_8
XFILLER_25_72 VDD VDD VSS VSS gf180mcu_fd_sc_mcu7t5v0__fillcap_64
XFILLER_2_10 VDD VDD VSS VSS gf180mcu_fd_sc_mcu7t5v0__fillcap_16
X_1310_ _1885_/Q _1877_/Q _1869_/Q _1861_/Q _1311_/S0 _1311_/S1 _1310_/Z VDD VDD VSS
+ VSS gf180mcu_fd_sc_mcu7t5v0__mux4_1
X_1241_ _1247_/A1 _1241_/A2 _1242_/A2 _2143_/D VDD VDD VSS VSS gf180mcu_fd_sc_mcu7t5v0__nor3_1
X_1172_ _1172_/A1 _2192_/Q _1172_/B _2194_/D VDD VDD VSS VSS gf180mcu_fd_sc_mcu7t5v0__oai21_1
XFILLER_49_263 VDD VDD VSS VSS gf180mcu_fd_sc_mcu7t5v0__fillcap_8
XFILLER_77_594 VDD VDD VSS VSS gf180mcu_fd_sc_mcu7t5v0__fillcap_8
XFILLER_64_233 VDD VDD VSS VSS gf180mcu_fd_sc_mcu7t5v0__fillcap_8
XFILLER_92_597 VDD VDD VSS VSS gf180mcu_fd_sc_mcu7t5v0__fillcap_64
XFILLER_20_314 VDD VDD VSS VSS gf180mcu_fd_sc_mcu7t5v0__fill_1
X_0956_ _2079_/Q _1830_/A1 VDD VDD VSS VSS gf180mcu_fd_sc_mcu7t5v0__clkinv_1
Xoutput133 _1192_/Z wire297/I VDD VDD VSS VSS gf180mcu_fd_sc_mcu7t5v0__buf_1
Xoutput122 _1182_/Z wire307/I VDD VDD VSS VSS gf180mcu_fd_sc_mcu7t5v0__buf_1
Xclkbuf_5_6__f_periph_clk_i clkbuf_4_3_0_periph_clk_i/Z _2061_/CLK VDD VDD VSS VSS
+ gf180mcu_fd_sc_mcu7t5v0__clkbuf_16
Xoutput177 _2035_/Q wire383/I VDD VDD VSS VSS gf180mcu_fd_sc_mcu7t5v0__buf_1
Xoutput166 _1989_/Q wire394/I VDD VDD VSS VSS gf180mcu_fd_sc_mcu7t5v0__buf_1
Xoutput155 _1991_/Q wire405/I VDD VDD VSS VSS gf180mcu_fd_sc_mcu7t5v0__buf_1
Xoutput144 _1391_/ZN wire238/I VDD VDD VSS VSS gf180mcu_fd_sc_mcu7t5v0__buf_1
X_1508_ _1470_/Z _1918_/Q _1508_/S _1918_/D VDD VDD VSS VSS gf180mcu_fd_sc_mcu7t5v0__mux2_2
Xoutput199 _2009_/Q wire361/I VDD VDD VSS VSS gf180mcu_fd_sc_mcu7t5v0__buf_1
Xoutput188 _2022_/Q wire372/I VDD VDD VSS VSS gf180mcu_fd_sc_mcu7t5v0__buf_1
X_1439_ _2061_/Q _1885_/Q _1440_/S _1885_/D VDD VDD VSS VSS gf180mcu_fd_sc_mcu7t5v0__mux2_2
XFILLER_87_347 VDD VDD VSS VSS gf180mcu_fd_sc_mcu7t5v0__fill_2
XFILLER_68_594 VDD VDD VSS VSS gf180mcu_fd_sc_mcu7t5v0__fill_1
XFILLER_55_277 VDD VDD VSS VSS gf180mcu_fd_sc_mcu7t5v0__fill_2
XFILLER_55_255 VDD VDD VSS VSS gf180mcu_fd_sc_mcu7t5v0__fillcap_16
XFILLER_62_37 VDD VDD VSS VSS gf180mcu_fd_sc_mcu7t5v0__fillcap_8
Xwire238 wire238/I cfg_data_o[9] VDD VDD VSS VSS gf180mcu_fd_sc_mcu7t5v0__clkbuf_3
Xwire227 wire227/I cfg_data_o[1] VDD VDD VSS VSS gf180mcu_fd_sc_mcu7t5v0__clkbuf_3
XPHY_EDGE_ROW_12_Left_111 VDD VSS gf180mcu_fd_sc_mcu7t5v0__endcap
XTAP_TAPCELL_ROW_94_1105 VDD VSS gf180mcu_fd_sc_mcu7t5v0__filltie
XFILLER_3_557 VDD VDD VSS VSS gf180mcu_fd_sc_mcu7t5v0__fill_2
XFILLER_78_314 VDD VDD VSS VSS gf180mcu_fd_sc_mcu7t5v0__fill_1
XPHY_EDGE_ROW_21_Left_120 VDD VSS gf180mcu_fd_sc_mcu7t5v0__endcap
XFILLER_93_306 VDD VDD VSS VSS gf180mcu_fd_sc_mcu7t5v0__fill_2
XTAP_TAPCELL_ROW_57_751 VDD VSS gf180mcu_fd_sc_mcu7t5v0__filltie
XTAP_TAPCELL_ROW_29_486 VDD VSS gf180mcu_fd_sc_mcu7t5v0__filltie
XFILLER_74_597 VDD VDD VSS VSS gf180mcu_fd_sc_mcu7t5v0__fillcap_4
XFILLER_15_664 VDD VDD VSS VSS gf180mcu_fd_sc_mcu7t5v0__fillcap_16
XFILLER_61_258 VDD VDD VSS VSS gf180mcu_fd_sc_mcu7t5v0__fillcap_8
XFILLER_30_612 VDD VDD VSS VSS gf180mcu_fd_sc_mcu7t5v0__fill_2
XFILLER_30_667 VDD VDD VSS VSS gf180mcu_fd_sc_mcu7t5v0__fill_2
X_1790_ _1799_/C _1790_/A2 _1790_/A3 _1792_/A2 VDD VDD VSS VSS gf180mcu_fd_sc_mcu7t5v0__nand3_1
Xinput13 cfg_data_i[16] input13/Z VDD VDD VSS VSS gf180mcu_fd_sc_mcu7t5v0__dlyb_1
XTAP_TAPCELL_ROW_12_331 VDD VSS gf180mcu_fd_sc_mcu7t5v0__filltie
Xinput24 cfg_data_i[26] input24/Z VDD VDD VSS VSS gf180mcu_fd_sc_mcu7t5v0__dlyb_1
Xinput35 cfg_data_i[7] input35/Z VDD VDD VSS VSS gf180mcu_fd_sc_mcu7t5v0__dlyb_1
Xinput46 cfg_rx_bytes_left_i[1] input46/Z VDD VDD VSS VSS gf180mcu_fd_sc_mcu7t5v0__dlyb_1
Xmax_cap527 _1431_/S _1426_/S VDD VDD VSS VSS gf180mcu_fd_sc_mcu7t5v0__clkbuf_1
Xinput79 cfg_tx_bytes_left_i[4] input79/Z VDD VDD VSS VSS gf180mcu_fd_sc_mcu7t5v0__dlyb_1
Xinput68 cfg_rx_pending_i input68/Z VDD VDD VSS VSS gf180mcu_fd_sc_mcu7t5v0__dlyb_1
Xinput57 cfg_rx_curr_addr_i[11] input57/Z VDD VDD VSS VSS gf180mcu_fd_sc_mcu7t5v0__dlyb_1
Xmax_cap549 _2161_/RN _2169_/RN VDD VDD VSS VSS gf180mcu_fd_sc_mcu7t5v0__buf_2
Xmax_cap538 _1587_/S _1601_/S VDD VDD VSS VSS gf180mcu_fd_sc_mcu7t5v0__buf_2
XFILLER_6_384 VDD VDD VSS VSS gf180mcu_fd_sc_mcu7t5v0__fill_1
XFILLER_97_689 VDD VDD VSS VSS gf180mcu_fd_sc_mcu7t5v0__fill_1
XFILLER_96_177 VDD VDD VSS VSS gf180mcu_fd_sc_mcu7t5v0__fillcap_64
X_1224_ _2138_/Q _1218_/Z _2139_/Q _1227_/A2 VDD VDD VSS VSS gf180mcu_fd_sc_mcu7t5v0__aoi21_1
XFILLER_65_520 VDD VDD VSS VSS gf180mcu_fd_sc_mcu7t5v0__fill_1
X_1155_ _1155_/A1 _1155_/A2 _1155_/A3 _1155_/A4 _1158_/A1 VDD VDD VSS VSS gf180mcu_fd_sc_mcu7t5v0__nand4_1
XFILLER_80_501 VDD VDD VSS VSS gf180mcu_fd_sc_mcu7t5v0__fill_1
XFILLER_25_417 VDD VDD VSS VSS gf180mcu_fd_sc_mcu7t5v0__fill_2
X_1086_ _1733_/A4 _1697_/B1 _1691_/C _1703_/C _1159_/A3 VDD VDD VSS VSS gf180mcu_fd_sc_mcu7t5v0__aoi211_1
XFILLER_52_247 VDD VDD VSS VSS gf180mcu_fd_sc_mcu7t5v0__fillcap_8
XFILLER_20_177 VDD VDD VSS VSS gf180mcu_fd_sc_mcu7t5v0__fill_2
X_1988_ _1988_/D _2031_/RN _2031_/CLK _1988_/Q VDD VDD VSS VSS gf180mcu_fd_sc_mcu7t5v0__dffrnq_1
X_0939_ _2167_/Q _1274_/A1 VDD VDD VSS VSS gf180mcu_fd_sc_mcu7t5v0__clkinv_1
XFILLER_88_667 VDD VDD VSS VSS gf180mcu_fd_sc_mcu7t5v0__fillcap_16
XFILLER_68_380 VDD VDD VSS VSS gf180mcu_fd_sc_mcu7t5v0__fillcap_4
XFILLER_28_233 VDD VDD VSS VSS gf180mcu_fd_sc_mcu7t5v0__fillcap_8
XTAP_TAPCELL_ROW_54_721 VDD VSS gf180mcu_fd_sc_mcu7t5v0__filltie
XFILLER_71_512 VDD VDD VSS VSS gf180mcu_fd_sc_mcu7t5v0__fillcap_32
XFILLER_56_597 VDD VDD VSS VSS gf180mcu_fd_sc_mcu7t5v0__fillcap_8
XTAP_TAPCELL_ROW_26_456 VDD VSS gf180mcu_fd_sc_mcu7t5v0__filltie
XFILLER_71_578 VDD VDD VSS VSS gf180mcu_fd_sc_mcu7t5v0__fillcap_8
XFILLER_12_667 VDD VDD VSS VSS gf180mcu_fd_sc_mcu7t5v0__fillcap_16
XFILLER_3_354 VDD VDD VSS VSS gf180mcu_fd_sc_mcu7t5v0__fill_1
XFILLER_3_332 VDD VDD VSS VSS gf180mcu_fd_sc_mcu7t5v0__fillcap_8
XFILLER_78_111 VDD VDD VSS VSS gf180mcu_fd_sc_mcu7t5v0__fill_2
XFILLER_78_177 VDD VDD VSS VSS gf180mcu_fd_sc_mcu7t5v0__fillcap_8
XFILLER_66_317 VDD VDD VSS VSS gf180mcu_fd_sc_mcu7t5v0__fillcap_4
XFILLER_14_8 VDD VDD VSS VSS gf180mcu_fd_sc_mcu7t5v0__fillcap_4
XFILLER_93_136 VDD VDD VSS VSS gf180mcu_fd_sc_mcu7t5v0__fillcap_4
XFILLER_47_542 VDD VDD VSS VSS gf180mcu_fd_sc_mcu7t5v0__fill_2
XFILLER_34_225 VDD VDD VSS VSS gf180mcu_fd_sc_mcu7t5v0__fillcap_16
XFILLER_74_383 VDD VDD VSS VSS gf180mcu_fd_sc_mcu7t5v0__fill_2
XFILLER_62_523 VDD VDD VSS VSS gf180mcu_fd_sc_mcu7t5v0__fill_2
XFILLER_34_247 VDD VDD VSS VSS gf180mcu_fd_sc_mcu7t5v0__fill_1
XFILLER_15_472 VDD VDD VSS VSS gf180mcu_fd_sc_mcu7t5v0__fill_2
X_1911_ _1911_/D _1927_/RN clkload4/I _1911_/Q VDD VDD VSS VSS gf180mcu_fd_sc_mcu7t5v0__dffrnq_1
X_1842_ _1964_/Q _2089_/Q _1849_/S _2089_/D VDD VDD VSS VSS gf180mcu_fd_sc_mcu7t5v0__mux2_2
XTAP_TAPCELL_ROW_60_779 VDD VSS gf180mcu_fd_sc_mcu7t5v0__filltie
X_1773_ _1813_/A1 _1789_/A2 _1913_/Q _1774_/A3 VDD VDD VSS VSS gf180mcu_fd_sc_mcu7t5v0__nand3_1
XTAP_TAPCELL_ROW_68_857 VDD VSS gf180mcu_fd_sc_mcu7t5v0__filltie
X_1207_ _2133_/Q _1201_/Z _2134_/Q _1209_/A2 VDD VDD VSS VSS gf180mcu_fd_sc_mcu7t5v0__aoi21_1
X_2187_ _2187_/D _2187_/RN _2187_/CLK _2187_/Q VDD VDD VSS VSS gf180mcu_fd_sc_mcu7t5v0__dffrnq_1
XFILLER_93_692 VDD VDD VSS VSS gf180mcu_fd_sc_mcu7t5v0__fill_2
XFILLER_53_501 VDD VDD VSS VSS gf180mcu_fd_sc_mcu7t5v0__fillcap_16
XFILLER_38_597 VDD VDD VSS VSS gf180mcu_fd_sc_mcu7t5v0__fillcap_4
XFILLER_25_258 VDD VDD VSS VSS gf180mcu_fd_sc_mcu7t5v0__fillcap_4
X_1138_ _1138_/A1 _2162_/Q _1138_/B1 _2169_/Q _1149_/A2 VDD VDD VSS VSS gf180mcu_fd_sc_mcu7t5v0__aoi22_1
X_1069_ _2099_/Q _2175_/Q _1070_/A2 VDD VDD VSS VSS gf180mcu_fd_sc_mcu7t5v0__nand2_1
XFILLER_4_107 VDD VDD VSS VSS gf180mcu_fd_sc_mcu7t5v0__fillcap_4
XFILLER_0_324 VDD VDD VSS VSS gf180mcu_fd_sc_mcu7t5v0__fill_2
XFILLER_88_497 VDD VDD VSS VSS gf180mcu_fd_sc_mcu7t5v0__fill_2
XFILLER_76_648 VDD VDD VSS VSS gf180mcu_fd_sc_mcu7t5v0__fill_1
XFILLER_75_114 VDD VDD VSS VSS gf180mcu_fd_sc_mcu7t5v0__fill_1
XTAP_TAPCELL_ROW_89_1059 VDD VSS gf180mcu_fd_sc_mcu7t5v0__filltie
XFILLER_16_247 VDD VDD VSS VSS gf180mcu_fd_sc_mcu7t5v0__fillcap_8
XTAP_TAPCELL_ROW_39_581 VDD VSS gf180mcu_fd_sc_mcu7t5v0__filltie
XFILLER_33_72 VDD VDD VSS VSS gf180mcu_fd_sc_mcu7t5v0__fillcap_16
XFILLER_8_457 VDD VDD VSS VSS gf180mcu_fd_sc_mcu7t5v0__fillcap_8
XFILLER_98_206 VDD VDD VSS VSS gf180mcu_fd_sc_mcu7t5v0__fillcap_32
X_2110_ _2110_/D _2187_/RN clkload3/I _2110_/Q VDD VDD VSS VSS gf180mcu_fd_sc_mcu7t5v0__dffrnq_1
XFILLER_66_125 VDD VDD VSS VSS gf180mcu_fd_sc_mcu7t5v0__fillcap_8
XFILLER_66_103 VDD VDD VSS VSS gf180mcu_fd_sc_mcu7t5v0__fill_2
XFILLER_39_328 VDD VDD VSS VSS gf180mcu_fd_sc_mcu7t5v0__fillcap_4
X_2041_ _2041_/D _2115_/RN _2191_/CLK _2041_/Q VDD VDD VSS VSS gf180mcu_fd_sc_mcu7t5v0__dffrnq_1
XTAP_TAPCELL_ROW_65_827 VDD VSS gf180mcu_fd_sc_mcu7t5v0__filltie
XFILLER_75_692 VDD VDD VSS VSS gf180mcu_fd_sc_mcu7t5v0__fill_2
XFILLER_81_139 VDD VDD VSS VSS gf180mcu_fd_sc_mcu7t5v0__fill_1
XFILLER_95_2 VDD VDD VSS VSS gf180mcu_fd_sc_mcu7t5v0__fillcap_64
XTAP_TAPCELL_ROW_20_407 VDD VSS gf180mcu_fd_sc_mcu7t5v0__filltie
X_1825_ _2079_/Q _2080_/Q _1826_/A2 VDD VDD VSS VSS gf180mcu_fd_sc_mcu7t5v0__nand2_1
X_1756_ _1756_/A1 _1832_/A2 _1757_/B1 VDD VDD VSS VSS gf180mcu_fd_sc_mcu7t5v0__nor2_1
X_1687_ _2067_/Q _2159_/Q _1687_/Z VDD VDD VSS VSS gf180mcu_fd_sc_mcu7t5v0__xor2_1
XFILLER_89_206 VDD VDD VSS VSS gf180mcu_fd_sc_mcu7t5v0__fillcap_4
XFILLER_57_136 VDD VDD VSS VSS gf180mcu_fd_sc_mcu7t5v0__fillcap_4
XFILLER_73_629 VDD VDD VSS VSS gf180mcu_fd_sc_mcu7t5v0__fill_1
XFILLER_53_342 VDD VDD VSS VSS gf180mcu_fd_sc_mcu7t5v0__fill_1
XTAP_TAPCELL_ROW_36_551 VDD VSS gf180mcu_fd_sc_mcu7t5v0__filltie
XTAP_TAPCELL_ROW_0_198 VDD VSS gf180mcu_fd_sc_mcu7t5v0__filltie
XFILLER_70_37 VDD VDD VSS VSS gf180mcu_fd_sc_mcu7t5v0__fillcap_16
XFILLER_5_416 VDD VDD VSS VSS gf180mcu_fd_sc_mcu7t5v0__fillcap_4
XTAP_TAPCELL_ROW_8_287 VDD VSS gf180mcu_fd_sc_mcu7t5v0__filltie
XFILLER_1_688 VDD VDD VSS VSS gf180mcu_fd_sc_mcu7t5v0__fillcap_4
XFILLER_48_169 VDD VDD VSS VSS gf180mcu_fd_sc_mcu7t5v0__fill_1
XFILLER_17_523 VDD VDD VSS VSS gf180mcu_fd_sc_mcu7t5v0__fill_2
XFILLER_63_139 VDD VDD VSS VSS gf180mcu_fd_sc_mcu7t5v0__fill_1
XFILLER_57_692 VDD VDD VSS VSS gf180mcu_fd_sc_mcu7t5v0__fill_2
XFILLER_17_578 VDD VDD VSS VSS gf180mcu_fd_sc_mcu7t5v0__fill_2
XFILLER_71_150 VDD VDD VSS VSS gf180mcu_fd_sc_mcu7t5v0__fillcap_4
XPHY_EDGE_ROW_4_Left_103 VDD VSS gf180mcu_fd_sc_mcu7t5v0__endcap
XFILLER_71_161 VDD VDD VSS VSS gf180mcu_fd_sc_mcu7t5v0__fill_2
XTAP_TAPCELL_ROW_70_874 VDD VSS gf180mcu_fd_sc_mcu7t5v0__filltie
X_1610_ input33/Z _1983_/Q _1611_/S _1983_/D VDD VDD VSS VSS gf180mcu_fd_sc_mcu7t5v0__mux2_2
X_1541_ _2108_/Q _1822_/B _1545_/S VDD VDD VSS VSS gf180mcu_fd_sc_mcu7t5v0__nand2_1
X_1472_ _1947_/Q _1955_/Q _1472_/S _1472_/Z VDD VDD VSS VSS gf180mcu_fd_sc_mcu7t5v0__mux2_2
XFILLER_79_294 VDD VDD VSS VSS gf180mcu_fd_sc_mcu7t5v0__fill_2
XFILLER_10_2 VDD VDD VSS VSS gf180mcu_fd_sc_mcu7t5v0__fillcap_32
XTAP_TAPCELL_ROW_78_952 VDD VSS gf180mcu_fd_sc_mcu7t5v0__filltie
XFILLER_67_489 VDD VDD VSS VSS gf180mcu_fd_sc_mcu7t5v0__fill_1
X_2024_ _2024_/D _2032_/RN _2024_/CLK _2024_/Q VDD VDD VSS VSS gf180mcu_fd_sc_mcu7t5v0__dffrnq_1
XFILLER_35_364 VDD VDD VSS VSS gf180mcu_fd_sc_mcu7t5v0__fill_1
XPHY_EDGE_ROW_59_Left_158 VDD VSS gf180mcu_fd_sc_mcu7t5v0__endcap
XFILLER_40_18 VDD VDD VSS VSS gf180mcu_fd_sc_mcu7t5v0__fillcap_8
X_1808_ _1822_/B _1808_/A2 _1809_/A2 VDD VDD VSS VSS gf180mcu_fd_sc_mcu7t5v0__nand2_1
X_1739_ _1739_/A1 _2080_/Q _1739_/B _1740_/A2 VDD VDD VSS VSS gf180mcu_fd_sc_mcu7t5v0__aoi21_1
XPHY_EDGE_ROW_68_Left_167 VDD VSS gf180mcu_fd_sc_mcu7t5v0__endcap
XFILLER_77_209 VDD VDD VSS VSS gf180mcu_fd_sc_mcu7t5v0__fill_1
XTAP_TAPCELL_ROW_5_257 VDD VSS gf180mcu_fd_sc_mcu7t5v0__filltie
XTAP_TAPCELL_ROW_86_1029 VDD VSS gf180mcu_fd_sc_mcu7t5v0__filltie
XFILLER_65_59 VDD VDD VSS VSS gf180mcu_fd_sc_mcu7t5v0__fillcap_8
XPHY_EDGE_ROW_77_Left_176 VDD VSS gf180mcu_fd_sc_mcu7t5v0__endcap
XFILLER_53_150 VDD VDD VSS VSS gf180mcu_fd_sc_mcu7t5v0__fillcap_4
XFILLER_81_492 VDD VDD VSS VSS gf180mcu_fd_sc_mcu7t5v0__fillcap_32
XFILLER_22_581 VDD VDD VSS VSS gf180mcu_fd_sc_mcu7t5v0__fill_2
XTAP_TAPCELL_ROW_97_1136 VDD VSS gf180mcu_fd_sc_mcu7t5v0__filltie
XPHY_EDGE_ROW_86_Left_185 VDD VSS gf180mcu_fd_sc_mcu7t5v0__endcap
XFILLER_5_246 VDD VDD VSS VSS gf180mcu_fd_sc_mcu7t5v0__fill_2
XFILLER_5_279 VDD VDD VSS VSS gf180mcu_fd_sc_mcu7t5v0__fill_1
XFILLER_68_209 VDD VDD VSS VSS gf180mcu_fd_sc_mcu7t5v0__fillcap_16
XTAP_TAPCELL_ROW_75_922 VDD VSS gf180mcu_fd_sc_mcu7t5v0__filltie
XFILLER_76_275 VDD VDD VSS VSS gf180mcu_fd_sc_mcu7t5v0__fillcap_32
XFILLER_49_489 VDD VDD VSS VSS gf180mcu_fd_sc_mcu7t5v0__fill_1
XPHY_EDGE_ROW_95_Left_194 VDD VSS gf180mcu_fd_sc_mcu7t5v0__endcap
XFILLER_91_212 VDD VDD VSS VSS gf180mcu_fd_sc_mcu7t5v0__fillcap_64
XTAP_TAPCELL_ROW_47_657 VDD VSS gf180mcu_fd_sc_mcu7t5v0__filltie
XFILLER_44_150 VDD VDD VSS VSS gf180mcu_fd_sc_mcu7t5v0__fill_1
XFILLER_20_518 VDD VDD VSS VSS gf180mcu_fd_sc_mcu7t5v0__fill_1
XFILLER_32_378 VDD VDD VSS VSS gf180mcu_fd_sc_mcu7t5v0__fillcap_4
X_0972_ input32/Z _0968_/Z _0973_/A3 _1673_/A3 _2117_/D VDD VDD VSS VSS gf180mcu_fd_sc_mcu7t5v0__and4_1
XTAP_TAPCELL_ROW_30_502 VDD VSS gf180mcu_fd_sc_mcu7t5v0__filltie
XFILLER_71_80 VDD VDD VSS VSS gf180mcu_fd_sc_mcu7t5v0__fillcap_16
XFILLER_58_2 VDD VDD VSS VSS gf180mcu_fd_sc_mcu7t5v0__fillcap_32
X_1524_ _1524_/A1 _1926_/Q _1525_/B VDD VDD VSS VSS gf180mcu_fd_sc_mcu7t5v0__nand2_1
XFILLER_59_209 VDD VDD VSS VSS gf180mcu_fd_sc_mcu7t5v0__fill_1
X_1455_ _1578_/A1 _1580_/A1 _2127_/Q _2128_/Q _1455_/ZN VDD VDD VSS VSS gf180mcu_fd_sc_mcu7t5v0__aoi22_1
X_1386_ _2106_/D _1179_/Z _1393_/B1 input65/Z _1388_/A1 VDD VDD VSS VSS gf180mcu_fd_sc_mcu7t5v0__aoi22_1
XTAP_TAPCELL_ROW_2_227 VDD VSS gf180mcu_fd_sc_mcu7t5v0__filltie
XFILLER_95_562 VDD VDD VSS VSS gf180mcu_fd_sc_mcu7t5v0__fillcap_64
XFILLER_67_264 VDD VDD VSS VSS gf180mcu_fd_sc_mcu7t5v0__fillcap_8
XFILLER_27_139 VDD VDD VSS VSS gf180mcu_fd_sc_mcu7t5v0__fill_1
XFILLER_55_448 VDD VDD VSS VSS gf180mcu_fd_sc_mcu7t5v0__fill_2
XFILLER_55_426 VDD VDD VSS VSS gf180mcu_fd_sc_mcu7t5v0__fill_2
X_2007_ _2007_/D _2020_/RN _2021_/CLK _2007_/Q VDD VDD VSS VSS gf180mcu_fd_sc_mcu7t5v0__dffrnq_1
XFILLER_51_632 VDD VDD VSS VSS gf180mcu_fd_sc_mcu7t5v0__fillcap_32
XFILLER_23_334 VDD VDD VSS VSS gf180mcu_fd_sc_mcu7t5v0__fill_1
XTAP_TAPCELL_ROW_18_381 VDD VSS gf180mcu_fd_sc_mcu7t5v0__filltie
Xwire409 wire409/I cfg_rx_size_o[12] VDD VDD VSS VSS gf180mcu_fd_sc_mcu7t5v0__clkbuf_3
XFILLER_2_238 VDD VDD VSS VSS gf180mcu_fd_sc_mcu7t5v0__fill_1
XTAP_TAPCELL_ROW_92_1088 VDD VSS gf180mcu_fd_sc_mcu7t5v0__filltie
XFILLER_58_242 VDD VDD VSS VSS gf180mcu_fd_sc_mcu7t5v0__fill_2
XFILLER_46_404 VDD VDD VSS VSS gf180mcu_fd_sc_mcu7t5v0__fillcap_16
XFILLER_73_212 VDD VDD VSS VSS gf180mcu_fd_sc_mcu7t5v0__fillcap_8
XFILLER_46_437 VDD VDD VSS VSS gf180mcu_fd_sc_mcu7t5v0__fill_2
XTAP_TAPCELL_ROW_44_627 VDD VSS gf180mcu_fd_sc_mcu7t5v0__filltie
XFILLER_14_345 VDD VDD VSS VSS gf180mcu_fd_sc_mcu7t5v0__fill_2
XFILLER_14_356 VDD VDD VSS VSS gf180mcu_fd_sc_mcu7t5v0__fillcap_8
XFILLER_41_72 VDD VDD VSS VSS gf180mcu_fd_sc_mcu7t5v0__fillcap_32
XFILLER_1_282 VDD VDD VSS VSS gf180mcu_fd_sc_mcu7t5v0__fill_2
X_1240_ _1240_/A1 _1240_/A2 _1240_/A3 _1240_/A4 _1246_/A3 VDD VDD VSS VSS gf180mcu_fd_sc_mcu7t5v0__nor4_1
XFILLER_96_359 VDD VDD VSS VSS gf180mcu_fd_sc_mcu7t5v0__fill_1
X_1171_ _1415_/A1 _1415_/A4 _1172_/B VDD VDD VSS VSS gf180mcu_fd_sc_mcu7t5v0__nand2_1
XFILLER_92_510 VDD VDD VSS VSS gf180mcu_fd_sc_mcu7t5v0__fillcap_8
XFILLER_77_562 VDD VDD VSS VSS gf180mcu_fd_sc_mcu7t5v0__fillcap_32
XFILLER_64_201 VDD VDD VSS VSS gf180mcu_fd_sc_mcu7t5v0__fillcap_32
Xclkbuf_5_29__f_periph_clk_i clkbuf_4_14_0_periph_clk_i/Z _2100_/CLK VDD VDD VSS VSS
+ gf180mcu_fd_sc_mcu7t5v0__clkbuf_16
XFILLER_66_91 VDD VDD VSS VSS gf180mcu_fd_sc_mcu7t5v0__fillcap_8
XFILLER_45_481 VDD VDD VSS VSS gf180mcu_fd_sc_mcu7t5v0__fillcap_8
XFILLER_45_492 VDD VDD VSS VSS gf180mcu_fd_sc_mcu7t5v0__fill_2
XTAP_TAPCELL_ROW_15_351 VDD VSS gf180mcu_fd_sc_mcu7t5v0__filltie
XFILLER_60_451 VDD VDD VSS VSS gf180mcu_fd_sc_mcu7t5v0__fillcap_4
X_0955_ _2065_/Q _1730_/A2 VDD VDD VSS VSS gf180mcu_fd_sc_mcu7t5v0__clkinv_1
Xoutput134 _1193_/Z wire296/I VDD VDD VSS VSS gf180mcu_fd_sc_mcu7t5v0__buf_1
Xoutput123 _1183_/Z wire306/I VDD VDD VSS VSS gf180mcu_fd_sc_mcu7t5v0__buf_1
Xoutput167 _1979_/Q wire393/I VDD VDD VSS VSS gf180mcu_fd_sc_mcu7t5v0__buf_1
Xoutput156 _1992_/Q wire404/I VDD VDD VSS VSS gf180mcu_fd_sc_mcu7t5v0__buf_1
Xoutput145 _2115_/Q wire415/I VDD VDD VSS VSS gf180mcu_fd_sc_mcu7t5v0__buf_1
X_1507_ _1468_/Z _1917_/Q _1508_/S _1917_/D VDD VDD VSS VSS gf180mcu_fd_sc_mcu7t5v0__mux2_2
Xoutput189 _2023_/Q wire371/I VDD VDD VSS VSS gf180mcu_fd_sc_mcu7t5v0__buf_1
Xoutput178 _2114_/Q wire382/I VDD VDD VSS VSS gf180mcu_fd_sc_mcu7t5v0__buf_1
X_1438_ _2060_/Q _1884_/Q _1441_/S _1884_/D VDD VDD VSS VSS gf180mcu_fd_sc_mcu7t5v0__mux2_2
X_1369_ input61/Z _1393_/B1 _1392_/B1 input91/Z _1369_/C _1372_/A1 VDD VDD VSS VSS
+ gf180mcu_fd_sc_mcu7t5v0__aoi221_1
XFILLER_55_223 VDD VDD VSS VSS gf180mcu_fd_sc_mcu7t5v0__fillcap_32
XFILLER_55_212 VDD VDD VSS VSS gf180mcu_fd_sc_mcu7t5v0__fill_2
XFILLER_62_16 VDD VDD VSS VSS gf180mcu_fd_sc_mcu7t5v0__fillcap_16
XFILLER_23_142 VDD VDD VSS VSS gf180mcu_fd_sc_mcu7t5v0__fillcap_8
XFILLER_62_49 VDD VDD VSS VSS gf180mcu_fd_sc_mcu7t5v0__fill_1
XFILLER_11_348 VDD VDD VSS VSS gf180mcu_fd_sc_mcu7t5v0__fill_2
Xwire239 wire239/I cfg_data_o[8] VDD VDD VSS VSS gf180mcu_fd_sc_mcu7t5v0__clkbuf_3
XTAP_TAPCELL_ROW_94_1106 VDD VSS gf180mcu_fd_sc_mcu7t5v0__filltie
Xfanout350 _1883_/RN _2155_/RN VDD VDD VSS VSS gf180mcu_fd_sc_mcu7t5v0__dlyb_1
XFILLER_59_540 VDD VDD VSS VSS gf180mcu_fd_sc_mcu7t5v0__fillcap_4
XFILLER_59_562 VDD VDD VSS VSS gf180mcu_fd_sc_mcu7t5v0__fillcap_16
XFILLER_86_381 VDD VDD VSS VSS gf180mcu_fd_sc_mcu7t5v0__fillcap_4
XFILLER_74_521 VDD VDD VSS VSS gf180mcu_fd_sc_mcu7t5v0__fillcap_4
XTAP_TAPCELL_ROW_57_752 VDD VSS gf180mcu_fd_sc_mcu7t5v0__filltie
XTAP_TAPCELL_ROW_29_487 VDD VSS gf180mcu_fd_sc_mcu7t5v0__filltie
XFILLER_74_587 VDD VDD VSS VSS gf180mcu_fd_sc_mcu7t5v0__fillcap_8
XFILLER_15_632 VDD VDD VSS VSS gf180mcu_fd_sc_mcu7t5v0__fillcap_32
XFILLER_27_492 VDD VDD VSS VSS gf180mcu_fd_sc_mcu7t5v0__fillcap_16
XFILLER_42_451 VDD VDD VSS VSS gf180mcu_fd_sc_mcu7t5v0__fillcap_4
Xinput14 cfg_data_i[17] input14/Z VDD VDD VSS VSS gf180mcu_fd_sc_mcu7t5v0__dlyb_1
Xinput25 cfg_data_i[27] input25/Z VDD VDD VSS VSS gf180mcu_fd_sc_mcu7t5v0__dlyb_1
Xinput36 cfg_data_i[8] input36/Z VDD VDD VSS VSS gf180mcu_fd_sc_mcu7t5v0__dlyb_1
Xinput47 cfg_rx_bytes_left_i[2] input47/Z VDD VDD VSS VSS gf180mcu_fd_sc_mcu7t5v0__dlyb_1
Xinput69 cfg_tx_bytes_left_i[0] input69/Z VDD VDD VSS VSS gf180mcu_fd_sc_mcu7t5v0__dlyb_1
Xinput58 cfg_rx_curr_addr_i[1] input58/Z VDD VDD VSS VSS gf180mcu_fd_sc_mcu7t5v0__dlyb_1
Xmax_cap539 _1561_/S _1565_/S VDD VDD VSS VSS gf180mcu_fd_sc_mcu7t5v0__clkbuf_2
Xmax_cap528 _1430_/S _1431_/S VDD VDD VSS VSS gf180mcu_fd_sc_mcu7t5v0__clkbuf_1
XFILLER_96_101 VDD VDD VSS VSS gf180mcu_fd_sc_mcu7t5v0__fillcap_4
X_1223_ _1230_/A1 _1223_/A2 _1222_/Z _2138_/D VDD VDD VSS VSS gf180mcu_fd_sc_mcu7t5v0__nor3_1
XFILLER_77_381 VDD VDD VSS VSS gf180mcu_fd_sc_mcu7t5v0__fillcap_4
X_1154_ _1154_/A1 _2168_/Q _1257_/A1 _2088_/Q _1155_/A4 VDD VDD VSS VSS gf180mcu_fd_sc_mcu7t5v0__aoi22_1
XFILLER_37_278 VDD VDD VSS VSS gf180mcu_fd_sc_mcu7t5v0__fill_2
X_1085_ _1700_/B _1690_/A1 _1110_/A2 VDD VDD VSS VSS gf180mcu_fd_sc_mcu7t5v0__nor2_1
XFILLER_92_384 VDD VDD VSS VSS gf180mcu_fd_sc_mcu7t5v0__fill_1
XFILLER_80_524 VDD VDD VSS VSS gf180mcu_fd_sc_mcu7t5v0__fill_1
XFILLER_65_587 VDD VDD VSS VSS gf180mcu_fd_sc_mcu7t5v0__fill_1
XFILLER_92_395 VDD VDD VSS VSS gf180mcu_fd_sc_mcu7t5v0__fill_2
XFILLER_20_101 VDD VDD VSS VSS gf180mcu_fd_sc_mcu7t5v0__fillcap_4
XFILLER_33_484 VDD VDD VSS VSS gf180mcu_fd_sc_mcu7t5v0__fillcap_4
X_1987_ _1987_/D _2031_/RN clkload0/I _1987_/Q VDD VDD VSS VSS gf180mcu_fd_sc_mcu7t5v0__dffrnq_1
X_0938_ _2166_/Q _1270_/A2 VDD VDD VSS VSS gf180mcu_fd_sc_mcu7t5v0__clkinv_1
XTAP_TAPCELL_ROW_54_722 VDD VSS gf180mcu_fd_sc_mcu7t5v0__filltie
XFILLER_73_37 VDD VDD VSS VSS gf180mcu_fd_sc_mcu7t5v0__fillcap_16
XTAP_TAPCELL_ROW_26_457 VDD VSS gf180mcu_fd_sc_mcu7t5v0__filltie
XFILLER_79_624 VDD VDD VSS VSS gf180mcu_fd_sc_mcu7t5v0__fillcap_4
XFILLER_3_366 VDD VDD VSS VSS gf180mcu_fd_sc_mcu7t5v0__fillcap_8
XFILLER_74_351 VDD VDD VSS VSS gf180mcu_fd_sc_mcu7t5v0__fill_1
X_1910_ _1910_/D _1923_/RN clkload5/I _1910_/Q VDD VDD VSS VSS gf180mcu_fd_sc_mcu7t5v0__dffrnq_1
XFILLER_30_465 VDD VDD VSS VSS gf180mcu_fd_sc_mcu7t5v0__fillcap_4
X_1841_ _1963_/Q _2088_/Q _1848_/S _2088_/D VDD VDD VSS VSS gf180mcu_fd_sc_mcu7t5v0__mux2_2
X_1772_ _1821_/A2 _1921_/Q _1774_/A2 VDD VDD VSS VSS gf180mcu_fd_sc_mcu7t5v0__nand2_1
XFILLER_7_672 VDD VDD VSS VSS gf180mcu_fd_sc_mcu7t5v0__fillcap_4
XFILLER_6_193 VDD VDD VSS VSS gf180mcu_fd_sc_mcu7t5v0__fillcap_4
XFILLER_97_443 VDD VDD VSS VSS gf180mcu_fd_sc_mcu7t5v0__fill_2
X_2186_ _2186_/D _2187_/RN _2188_/CLK _2186_/Q VDD VDD VSS VSS gf180mcu_fd_sc_mcu7t5v0__dffrnq_1
X_1206_ _1230_/A1 _1206_/A2 _1205_/Z _2133_/D VDD VDD VSS VSS gf180mcu_fd_sc_mcu7t5v0__nor3_1
XTAP_TAPCELL_ROW_68_858 VDD VSS gf180mcu_fd_sc_mcu7t5v0__filltie
X_1137_ _2093_/Q _1280_/A1 _1281_/A1 _2094_/Q _1149_/A1 VDD VDD VSS VSS gf180mcu_fd_sc_mcu7t5v0__aoi22_1
XPHY_EDGE_ROW_40_Left_139 VDD VSS gf180mcu_fd_sc_mcu7t5v0__endcap
X_1068_ _2099_/Q _2175_/Q _1068_/Z VDD VDD VSS VSS gf180mcu_fd_sc_mcu7t5v0__or2_1
XTAP_TAPCELL_ROW_23_427 VDD VSS gf180mcu_fd_sc_mcu7t5v0__filltie
XFILLER_80_387 VDD VDD VSS VSS gf180mcu_fd_sc_mcu7t5v0__fillcap_16
XFILLER_40_229 VDD VDD VSS VSS gf180mcu_fd_sc_mcu7t5v0__fillcap_16
XFILLER_88_454 VDD VDD VSS VSS gf180mcu_fd_sc_mcu7t5v0__fill_1
XFILLER_76_616 VDD VDD VSS VSS gf180mcu_fd_sc_mcu7t5v0__fillcap_32
XFILLER_75_104 VDD VDD VSS VSS gf180mcu_fd_sc_mcu7t5v0__fillcap_8
XFILLER_56_340 VDD VDD VSS VSS gf180mcu_fd_sc_mcu7t5v0__fill_1
XFILLER_90_107 VDD VDD VSS VSS gf180mcu_fd_sc_mcu7t5v0__fillcap_64
XFILLER_16_226 VDD VDD VSS VSS gf180mcu_fd_sc_mcu7t5v0__fill_2
XTAP_TAPCELL_ROW_39_582 VDD VSS gf180mcu_fd_sc_mcu7t5v0__filltie
XFILLER_84_693 VDD VDD VSS VSS gf180mcu_fd_sc_mcu7t5v0__fill_1
XFILLER_56_395 VDD VDD VSS VSS gf180mcu_fd_sc_mcu7t5v0__fillcap_8
XFILLER_44_535 VDD VDD VSS VSS gf180mcu_fd_sc_mcu7t5v0__fill_2
Xudma_uart_top_510 cfg_ready_o VDD VDD VSS VSS gf180mcu_fd_sc_mcu7t5v0__tieh
XFILLER_8_469 VDD VDD VSS VSS gf180mcu_fd_sc_mcu7t5v0__fill_2
XFILLER_67_627 VDD VDD VSS VSS gf180mcu_fd_sc_mcu7t5v0__fill_2
X_2040_ _2040_/D _2115_/RN clkload1/I _2040_/Q VDD VDD VSS VSS gf180mcu_fd_sc_mcu7t5v0__dffrnq_1
XFILLER_94_468 VDD VDD VSS VSS gf180mcu_fd_sc_mcu7t5v0__fill_2
XTAP_TAPCELL_ROW_65_828 VDD VSS gf180mcu_fd_sc_mcu7t5v0__filltie
XFILLER_47_384 VDD VDD VSS VSS gf180mcu_fd_sc_mcu7t5v0__fillcap_4
XFILLER_62_376 VDD VDD VSS VSS gf180mcu_fd_sc_mcu7t5v0__fillcap_8
XFILLER_88_2 VDD VDD VSS VSS gf180mcu_fd_sc_mcu7t5v0__fillcap_32
XFILLER_30_295 VDD VDD VSS VSS gf180mcu_fd_sc_mcu7t5v0__fillcap_16
X_1824_ _1760_/Z _1826_/B _2079_/Q _2079_/D VDD VDD VSS VSS gf180mcu_fd_sc_mcu7t5v0__mux2_2
X_1755_ _1755_/A1 _1755_/A2 _1757_/A2 VDD VDD VSS VSS gf180mcu_fd_sc_mcu7t5v0__nand2_1
X_1686_ _1449_/B _1686_/A2 _1686_/B _2051_/D VDD VDD VSS VSS gf180mcu_fd_sc_mcu7t5v0__oai21_1
XFILLER_85_457 VDD VDD VSS VSS gf180mcu_fd_sc_mcu7t5v0__fillcap_16
XFILLER_73_608 VDD VDD VSS VSS gf180mcu_fd_sc_mcu7t5v0__fill_2
XFILLER_72_107 VDD VDD VSS VSS gf180mcu_fd_sc_mcu7t5v0__fillcap_4
XFILLER_26_524 VDD VDD VSS VSS gf180mcu_fd_sc_mcu7t5v0__fill_1
X_2169_ _2169_/D _2169_/RN _2170_/CLK _2169_/Q VDD VDD VSS VSS gf180mcu_fd_sc_mcu7t5v0__dffrnq_1
XFILLER_66_693 VDD VDD VSS VSS gf180mcu_fd_sc_mcu7t5v0__fill_1
XFILLER_26_568 VDD VDD VSS VSS gf180mcu_fd_sc_mcu7t5v0__fill_1
XTAP_TAPCELL_ROW_36_552 VDD VSS gf180mcu_fd_sc_mcu7t5v0__filltie
XFILLER_80_151 VDD VDD VSS VSS gf180mcu_fd_sc_mcu7t5v0__fillcap_16
XTAP_TAPCELL_ROW_0_199 VDD VSS gf180mcu_fd_sc_mcu7t5v0__filltie
XFILLER_41_538 VDD VDD VSS VSS gf180mcu_fd_sc_mcu7t5v0__fillcap_16
XFILLER_5_428 VDD VDD VSS VSS gf180mcu_fd_sc_mcu7t5v0__fill_1
XFILLER_79_69 VDD VDD VSS VSS gf180mcu_fd_sc_mcu7t5v0__fill_1
XTAP_TAPCELL_ROW_8_288 VDD VSS gf180mcu_fd_sc_mcu7t5v0__filltie
XFILLER_88_273 VDD VDD VSS VSS gf180mcu_fd_sc_mcu7t5v0__fill_1
XFILLER_48_104 VDD VDD VSS VSS gf180mcu_fd_sc_mcu7t5v0__fill_1
XFILLER_76_457 VDD VDD VSS VSS gf180mcu_fd_sc_mcu7t5v0__fill_2
XFILLER_91_405 VDD VDD VSS VSS gf180mcu_fd_sc_mcu7t5v0__fill_1
XFILLER_91_438 VDD VDD VSS VSS gf180mcu_fd_sc_mcu7t5v0__fill_1
XFILLER_84_490 VDD VDD VSS VSS gf180mcu_fd_sc_mcu7t5v0__fillcap_4
XFILLER_17_557 VDD VDD VSS VSS gf180mcu_fd_sc_mcu7t5v0__fill_2
XFILLER_72_663 VDD VDD VSS VSS gf180mcu_fd_sc_mcu7t5v0__fill_2
XFILLER_32_516 VDD VDD VSS VSS gf180mcu_fd_sc_mcu7t5v0__fill_1
XTAP_TAPCELL_ROW_70_875 VDD VSS gf180mcu_fd_sc_mcu7t5v0__filltie
XFILLER_8_288 VDD VDD VSS VSS gf180mcu_fd_sc_mcu7t5v0__fill_2
X_1540_ _1537_/Z _1535_/Z _1540_/A3 _1743_/A1 VDD VDD VSS VSS gf180mcu_fd_sc_mcu7t5v0__nand3_1
X_1471_ _1470_/Z _1902_/Q _1473_/S _1902_/D VDD VDD VSS VSS gf180mcu_fd_sc_mcu7t5v0__mux2_2
XFILLER_69_80 VDD VDD VSS VSS gf180mcu_fd_sc_mcu7t5v0__fill_2
XTAP_TAPCELL_ROW_78_953 VDD VSS gf180mcu_fd_sc_mcu7t5v0__filltie
XFILLER_67_446 VDD VDD VSS VSS gf180mcu_fd_sc_mcu7t5v0__fill_2
X_2023_ _2023_/D _2117_/RN _2025_/CLK _2023_/Q VDD VDD VSS VSS gf180mcu_fd_sc_mcu7t5v0__dffrnq_1
XFILLER_82_449 VDD VDD VSS VSS gf180mcu_fd_sc_mcu7t5v0__fillcap_4
XFILLER_47_170 VDD VDD VSS VSS gf180mcu_fd_sc_mcu7t5v0__fillcap_32
XFILLER_62_173 VDD VDD VSS VSS gf180mcu_fd_sc_mcu7t5v0__fill_2
XTAP_TAPCELL_ROW_33_522 VDD VSS gf180mcu_fd_sc_mcu7t5v0__filltie
X_1807_ _1815_/A1 _1909_/Q _1901_/Q _1815_/B2 _1815_/C _1809_/A1 VDD VDD VSS VSS gf180mcu_fd_sc_mcu7t5v0__aoi221_1
X_1738_ _1738_/A1 _2079_/Q _1830_/A2 _2102_/Q _1740_/A1 VDD VDD VSS VSS gf180mcu_fd_sc_mcu7t5v0__aoi22_1
X_1669_ _1669_/A1 _1669_/A2 _2038_/D VDD VDD VSS VSS gf180mcu_fd_sc_mcu7t5v0__nand2_1
XTAP_TAPCELL_ROW_5_258 VDD VSS gf180mcu_fd_sc_mcu7t5v0__filltie
XFILLER_58_457 VDD VDD VSS VSS gf180mcu_fd_sc_mcu7t5v0__fillcap_4
XFILLER_58_435 VDD VDD VSS VSS gf180mcu_fd_sc_mcu7t5v0__fillcap_4
XFILLER_85_276 VDD VDD VSS VSS gf180mcu_fd_sc_mcu7t5v0__fillcap_4
XFILLER_26_310 VDD VDD VSS VSS gf180mcu_fd_sc_mcu7t5v0__fillcap_4
XFILLER_73_438 VDD VDD VSS VSS gf180mcu_fd_sc_mcu7t5v0__fillcap_4
XFILLER_14_516 VDD VDD VSS VSS gf180mcu_fd_sc_mcu7t5v0__fill_1
XTAP_TAPCELL_ROW_97_1137 VDD VSS gf180mcu_fd_sc_mcu7t5v0__filltie
XFILLER_30_85 VDD VDD VSS VSS gf180mcu_fd_sc_mcu7t5v0__fillcap_4
Xclkbuf_5_1__f_periph_clk_i clkbuf_4_0_0_periph_clk_i/Z clkload8/I VDD VDD VSS VSS
+ gf180mcu_fd_sc_mcu7t5v0__clkbuf_16
XFILLER_1_475 VDD VDD VSS VSS gf180mcu_fd_sc_mcu7t5v0__fillcap_8
XFILLER_39_72 VDD VDD VSS VSS gf180mcu_fd_sc_mcu7t5v0__fillcap_4
XFILLER_36_107 VDD VDD VSS VSS gf180mcu_fd_sc_mcu7t5v0__fillcap_16
XTAP_TAPCELL_ROW_75_923 VDD VSS gf180mcu_fd_sc_mcu7t5v0__filltie
XFILLER_17_332 VDD VDD VSS VSS gf180mcu_fd_sc_mcu7t5v0__fillcap_4
XTAP_TAPCELL_ROW_47_658 VDD VSS gf180mcu_fd_sc_mcu7t5v0__filltie
XFILLER_44_195 VDD VDD VSS VSS gf180mcu_fd_sc_mcu7t5v0__fill_1
X_0971_ _1332_/A3 _1376_/A2 _0973_/A3 _1673_/A3 _1634_/S VDD VDD VSS VSS gf180mcu_fd_sc_mcu7t5v0__nand4_1
XFILLER_9_553 VDD VDD VSS VSS gf180mcu_fd_sc_mcu7t5v0__fillcap_4
X_1523_ _1523_/A1 _1523_/A2 _1523_/B _1925_/D VDD VDD VSS VSS gf180mcu_fd_sc_mcu7t5v0__oai21_1
X_1454_ _2127_/Q _2128_/Q _1456_/B VDD VDD VSS VSS gf180mcu_fd_sc_mcu7t5v0__nand2_1
X_1385_ _1385_/A1 _1385_/A2 _1385_/ZN VDD VDD VSS VSS gf180mcu_fd_sc_mcu7t5v0__nand2_1
XTAP_TAPCELL_ROW_2_228 VDD VSS gf180mcu_fd_sc_mcu7t5v0__filltie
XFILLER_67_298 VDD VDD VSS VSS gf180mcu_fd_sc_mcu7t5v0__fillcap_8
X_2006_ _2006_/D _2115_/RN clkload1/I _2006_/Q VDD VDD VSS VSS gf180mcu_fd_sc_mcu7t5v0__dffrnq_1
XTAP_TAPCELL_ROW_18_382 VDD VSS gf180mcu_fd_sc_mcu7t5v0__filltie
XFILLER_50_154 VDD VDD VSS VSS gf180mcu_fd_sc_mcu7t5v0__fillcap_4
XTAP_TAPCELL_ROW_92_1089 VDD VSS gf180mcu_fd_sc_mcu7t5v0__filltie
XFILLER_76_37 VDD VDD VSS VSS gf180mcu_fd_sc_mcu7t5v0__fillcap_16
XFILLER_61_408 VDD VDD VSS VSS gf180mcu_fd_sc_mcu7t5v0__fill_1
XFILLER_14_313 VDD VDD VSS VSS gf180mcu_fd_sc_mcu7t5v0__fill_2
XTAP_TAPCELL_ROW_44_628 VDD VSS gf180mcu_fd_sc_mcu7t5v0__filltie
XFILLER_61_419 VDD VDD VSS VSS gf180mcu_fd_sc_mcu7t5v0__fill_1
Xclkbuf_5_16__f_periph_clk_i clkbuf_4_8_0_periph_clk_i/Z _2082_/CLK VDD VDD VSS VSS
+ gf180mcu_fd_sc_mcu7t5v0__clkbuf_16
XFILLER_81_290 VDD VDD VSS VSS gf180mcu_fd_sc_mcu7t5v0__fill_2
XFILLER_14_379 VDD VDD VSS VSS gf180mcu_fd_sc_mcu7t5v0__fillcap_4
XTAP_TAPCELL_ROW_80_970 VDD VSS gf180mcu_fd_sc_mcu7t5v0__filltie
XFILLER_6_523 VDD VDD VSS VSS gf180mcu_fd_sc_mcu7t5v0__fill_2
XFILLER_6_567 VDD VDD VSS VSS gf180mcu_fd_sc_mcu7t5v0__fillcap_8
XFILLER_69_508 VDD VDD VSS VSS gf180mcu_fd_sc_mcu7t5v0__fillcap_4
XFILLER_2_34 VDD VDD VSS VSS gf180mcu_fd_sc_mcu7t5v0__fill_1
XFILLER_89_390 VDD VDD VSS VSS gf180mcu_fd_sc_mcu7t5v0__fill_1
XFILLER_2_45 VDD VDD VSS VSS gf180mcu_fd_sc_mcu7t5v0__fillcap_4
X_1170_ _2155_/Q _2156_/Q _1170_/B _2052_/Q _1433_/B VDD VDD VSS VSS gf180mcu_fd_sc_mcu7t5v0__aoi211_1
XFILLER_92_522 VDD VDD VSS VSS gf180mcu_fd_sc_mcu7t5v0__fill_2
XFILLER_49_298 VDD VDD VSS VSS gf180mcu_fd_sc_mcu7t5v0__fill_2
XFILLER_18_663 VDD VDD VSS VSS gf180mcu_fd_sc_mcu7t5v0__fill_2
XFILLER_64_279 VDD VDD VSS VSS gf180mcu_fd_sc_mcu7t5v0__fillcap_32
XFILLER_52_419 VDD VDD VSS VSS gf180mcu_fd_sc_mcu7t5v0__fillcap_16
XFILLER_72_290 VDD VDD VSS VSS gf180mcu_fd_sc_mcu7t5v0__fillcap_16
XTAP_TAPCELL_ROW_15_352 VDD VSS gf180mcu_fd_sc_mcu7t5v0__filltie
X_0954_ _2064_/Q _1730_/A1 VDD VDD VSS VSS gf180mcu_fd_sc_mcu7t5v0__clkinv_1
XFILLER_70_2 VDD VDD VSS VSS gf180mcu_fd_sc_mcu7t5v0__fillcap_16
Xoutput124 _1356_/ZN wire227/I VDD VDD VSS VSS gf180mcu_fd_sc_mcu7t5v0__buf_1
Xoutput113 _1349_/ZN wire221/I VDD VDD VSS VSS gf180mcu_fd_sc_mcu7t5v0__buf_1
Xoutput168 _1980_/Q wire392/I VDD VDD VSS VSS gf180mcu_fd_sc_mcu7t5v0__buf_1
Xoutput157 _1993_/Q wire403/I VDD VDD VSS VSS gf180mcu_fd_sc_mcu7t5v0__buf_1
Xoutput146 _2006_/Q wire414/I VDD VDD VSS VSS gf180mcu_fd_sc_mcu7t5v0__buf_1
Xoutput135 _1360_/ZN wire242/I VDD VDD VSS VSS gf180mcu_fd_sc_mcu7t5v0__buf_1
X_1506_ _1466_/Z _1916_/Q _1508_/S _1916_/D VDD VDD VSS VSS gf180mcu_fd_sc_mcu7t5v0__mux2_2
Xoutput179 _2019_/Q wire381/I VDD VDD VSS VSS gf180mcu_fd_sc_mcu7t5v0__buf_1
X_1437_ _2059_/Q _1883_/Q _1441_/S _1883_/D VDD VDD VSS VSS gf180mcu_fd_sc_mcu7t5v0__mux2_2
XFILLER_87_349 VDD VDD VSS VSS gf180mcu_fd_sc_mcu7t5v0__fill_1
X_1368_ _1368_/A1 _1368_/A2 _1369_/C VDD VDD VSS VSS gf180mcu_fd_sc_mcu7t5v0__nand2_1
XFILLER_46_18 VDD VDD VSS VSS gf180mcu_fd_sc_mcu7t5v0__fillcap_16
X_1299_ _1303_/A1 _1303_/A3 _1301_/A2 VDD VDD VSS VSS gf180mcu_fd_sc_mcu7t5v0__nand2_1
XFILLER_83_555 VDD VDD VSS VSS gf180mcu_fd_sc_mcu7t5v0__fillcap_4
XFILLER_55_279 VDD VDD VSS VSS gf180mcu_fd_sc_mcu7t5v0__fill_1
XFILLER_23_154 VDD VDD VSS VSS gf180mcu_fd_sc_mcu7t5v0__fill_2
XFILLER_11_338 VDD VDD VSS VSS gf180mcu_fd_sc_mcu7t5v0__fillcap_4
XTAP_TAPCELL_ROW_94_1107 VDD VSS gf180mcu_fd_sc_mcu7t5v0__filltie
XFILLER_3_559 VDD VDD VSS VSS gf180mcu_fd_sc_mcu7t5v0__fill_1
Xfanout351 _1873_/RN _1874_/RN VDD VDD VSS VSS gf180mcu_fd_sc_mcu7t5v0__dlyb_1
XFILLER_19_416 VDD VDD VSS VSS gf180mcu_fd_sc_mcu7t5v0__fillcap_4
XFILLER_74_511 VDD VDD VSS VSS gf180mcu_fd_sc_mcu7t5v0__fill_1
XTAP_TAPCELL_ROW_57_753 VDD VSS gf180mcu_fd_sc_mcu7t5v0__filltie
XTAP_TAPCELL_ROW_29_488 VDD VSS gf180mcu_fd_sc_mcu7t5v0__filltie
XTAP_TAPCELL_ROW_12_322 VDD VSS gf180mcu_fd_sc_mcu7t5v0__filltie
Xinput15 cfg_data_i[18] input15/Z VDD VDD VSS VSS gf180mcu_fd_sc_mcu7t5v0__dlyb_1
Xinput26 cfg_data_i[28] input26/Z VDD VDD VSS VSS gf180mcu_fd_sc_mcu7t5v0__dlyb_1
Xinput37 cfg_data_i[9] input37/Z VDD VDD VSS VSS gf180mcu_fd_sc_mcu7t5v0__dlyb_1
Xinput48 cfg_rx_bytes_left_i[3] input48/Z VDD VDD VSS VSS gf180mcu_fd_sc_mcu7t5v0__dlyb_1
Xinput59 cfg_rx_curr_addr_i[2] input59/Z VDD VDD VSS VSS gf180mcu_fd_sc_mcu7t5v0__dlyb_1
Xmax_cap529 _1425_/S _1430_/S VDD VDD VSS VSS gf180mcu_fd_sc_mcu7t5v0__clkbuf_1
XFILLER_6_364 VDD VDD VSS VSS gf180mcu_fd_sc_mcu7t5v0__fillcap_16
XFILLER_2_581 VDD VDD VSS VSS gf180mcu_fd_sc_mcu7t5v0__fillcap_8
XFILLER_69_349 VDD VDD VSS VSS gf180mcu_fd_sc_mcu7t5v0__fill_1
X_1222_ _2135_/Q _2138_/Q _1208_/Z _1217_/Z _1222_/Z VDD VDD VSS VSS gf180mcu_fd_sc_mcu7t5v0__and4_1
XFILLER_77_80 VDD VDD VSS VSS gf180mcu_fd_sc_mcu7t5v0__fillcap_4
XFILLER_65_500 VDD VDD VSS VSS gf180mcu_fd_sc_mcu7t5v0__fillcap_16
X_1153_ _1153_/A1 _2170_/Q _1156_/A1 _2097_/Q _1155_/A3 VDD VDD VSS VSS gf180mcu_fd_sc_mcu7t5v0__aoi22_1
XFILLER_92_341 VDD VDD VSS VSS gf180mcu_fd_sc_mcu7t5v0__fill_2
XFILLER_25_408 VDD VDD VSS VSS gf180mcu_fd_sc_mcu7t5v0__fill_1
XFILLER_25_419 VDD VDD VSS VSS gf180mcu_fd_sc_mcu7t5v0__fill_1
X_1084_ _1697_/B1 _1691_/C _1703_/C _2053_/Q _1690_/A1 VDD VDD VSS VSS gf180mcu_fd_sc_mcu7t5v0__nor4_1
XFILLER_52_205 VDD VDD VSS VSS gf180mcu_fd_sc_mcu7t5v0__fillcap_4
XFILLER_18_493 VDD VDD VSS VSS gf180mcu_fd_sc_mcu7t5v0__fill_2
XFILLER_80_536 VDD VDD VSS VSS gf180mcu_fd_sc_mcu7t5v0__fillcap_8
XFILLER_45_290 VDD VDD VSS VSS gf180mcu_fd_sc_mcu7t5v0__fill_1
XFILLER_21_636 VDD VDD VSS VSS gf180mcu_fd_sc_mcu7t5v0__fillcap_4
X_1986_ _1986_/D _2034_/RN _2034_/CLK _1986_/Q VDD VDD VSS VSS gf180mcu_fd_sc_mcu7t5v0__dffrnq_1
X_0937_ _2165_/Q _1270_/A1 VDD VDD VSS VSS gf180mcu_fd_sc_mcu7t5v0__clkinv_1
XFILLER_56_522 VDD VDD VSS VSS gf180mcu_fd_sc_mcu7t5v0__fill_2
XFILLER_16_408 VDD VDD VSS VSS gf180mcu_fd_sc_mcu7t5v0__fillcap_16
XFILLER_83_352 VDD VDD VSS VSS gf180mcu_fd_sc_mcu7t5v0__fillcap_8
XTAP_TAPCELL_ROW_54_723 VDD VSS gf180mcu_fd_sc_mcu7t5v0__filltie
XTAP_TAPCELL_ROW_26_458 VDD VSS gf180mcu_fd_sc_mcu7t5v0__filltie
XFILLER_51_282 VDD VDD VSS VSS gf180mcu_fd_sc_mcu7t5v0__fillcap_16
XFILLER_51_260 VDD VDD VSS VSS gf180mcu_fd_sc_mcu7t5v0__fill_1
XFILLER_22_31 VDD VDD VSS VSS gf180mcu_fd_sc_mcu7t5v0__fillcap_4
XFILLER_0_2 VDD VDD VSS VSS gf180mcu_fd_sc_mcu7t5v0__fillcap_32
XFILLER_78_102 VDD VDD VSS VSS gf180mcu_fd_sc_mcu7t5v0__fill_2
XFILLER_78_124 VDD VDD VSS VSS gf180mcu_fd_sc_mcu7t5v0__fillcap_16
XFILLER_87_680 VDD VDD VSS VSS gf180mcu_fd_sc_mcu7t5v0__fillcap_8
XFILLER_47_72 VDD VDD VSS VSS gf180mcu_fd_sc_mcu7t5v0__fillcap_8
XFILLER_19_279 VDD VDD VSS VSS gf180mcu_fd_sc_mcu7t5v0__fill_1
XFILLER_47_566 VDD VDD VSS VSS gf180mcu_fd_sc_mcu7t5v0__fill_1
XFILLER_15_474 VDD VDD VSS VSS gf180mcu_fd_sc_mcu7t5v0__fill_1
X_1840_ _1962_/Q _2087_/Q _1849_/S _2087_/D VDD VDD VSS VSS gf180mcu_fd_sc_mcu7t5v0__mux2_2
XFILLER_11_680 VDD VDD VSS VSS gf180mcu_fd_sc_mcu7t5v0__fillcap_8
X_1771_ _1826_/A1 _1829_/A3 _2073_/Q _1832_/A2 _1777_/C VDD VDD VSS VSS gf180mcu_fd_sc_mcu7t5v0__nand4_1
Xmax_cap315 _1708_/S _1710_/S VDD VDD VSS VSS gf180mcu_fd_sc_mcu7t5v0__buf_2
XFILLER_97_422 VDD VDD VSS VSS gf180mcu_fd_sc_mcu7t5v0__fillcap_4
XFILLER_69_124 VDD VDD VSS VSS gf180mcu_fd_sc_mcu7t5v0__fillcap_16
XFILLER_78_691 VDD VDD VSS VSS gf180mcu_fd_sc_mcu7t5v0__fill_2
X_2185_ _2185_/D _2185_/RN clkload6/I _2185_/Q VDD VDD VSS VSS gf180mcu_fd_sc_mcu7t5v0__dffrnq_1
X_1205_ _2130_/Q _2131_/Q _2132_/Q _2133_/Q _1205_/Z VDD VDD VSS VSS gf180mcu_fd_sc_mcu7t5v0__and4_1
XTAP_TAPCELL_ROW_68_859 VDD VSS gf180mcu_fd_sc_mcu7t5v0__filltie
X_1136_ _1136_/A1 _1136_/A2 _1136_/A3 _1136_/A4 _1140_/A1 VDD VDD VSS VSS gf180mcu_fd_sc_mcu7t5v0__nand4_1
XFILLER_65_352 VDD VDD VSS VSS gf180mcu_fd_sc_mcu7t5v0__fillcap_8
XFILLER_25_216 VDD VDD VSS VSS gf180mcu_fd_sc_mcu7t5v0__fill_2
XFILLER_92_171 VDD VDD VSS VSS gf180mcu_fd_sc_mcu7t5v0__fillcap_4
X_1067_ _1065_/Z _1067_/A2 _1075_/A1 VDD VDD VSS VSS gf180mcu_fd_sc_mcu7t5v0__nand2_1
XTAP_TAPCELL_ROW_23_428 VDD VSS gf180mcu_fd_sc_mcu7t5v0__filltie
XFILLER_33_282 VDD VDD VSS VSS gf180mcu_fd_sc_mcu7t5v0__fillcap_16
X_1969_ _1969_/D _2092_/RN clkload7/I _1969_/Q VDD VDD VSS VSS gf180mcu_fd_sc_mcu7t5v0__dffrnq_1
XFILLER_48_308 VDD VDD VSS VSS gf180mcu_fd_sc_mcu7t5v0__fillcap_4
XFILLER_69_680 VDD VDD VSS VSS gf180mcu_fd_sc_mcu7t5v0__fillcap_8
XFILLER_84_37 VDD VDD VSS VSS gf180mcu_fd_sc_mcu7t5v0__fillcap_64
XFILLER_29_577 VDD VDD VSS VSS gf180mcu_fd_sc_mcu7t5v0__fillcap_8
XFILLER_84_683 VDD VDD VSS VSS gf180mcu_fd_sc_mcu7t5v0__fillcap_8
XFILLER_84_661 VDD VDD VSS VSS gf180mcu_fd_sc_mcu7t5v0__fillcap_4
XFILLER_17_64 VDD VDD VSS VSS gf180mcu_fd_sc_mcu7t5v0__fillcap_4
XTAP_TAPCELL_ROW_39_583 VDD VSS gf180mcu_fd_sc_mcu7t5v0__filltie
XFILLER_71_311 VDD VDD VSS VSS gf180mcu_fd_sc_mcu7t5v0__fillcap_4
XFILLER_31_208 VDD VDD VSS VSS gf180mcu_fd_sc_mcu7t5v0__fill_2
Xudma_uart_top_500 data_rx_o[24] VDD VDD VSS VSS gf180mcu_fd_sc_mcu7t5v0__tiel
XFILLER_8_448 VDD VDD VSS VSS gf180mcu_fd_sc_mcu7t5v0__fillcap_4
XFILLER_3_142 VDD VDD VSS VSS gf180mcu_fd_sc_mcu7t5v0__fill_1
Xclkbuf_4_6_0_periph_clk_i clkbuf_0_periph_clk_i/Z clkbuf_4_6_0_periph_clk_i/Z VDD
+ VDD VSS VSS gf180mcu_fd_sc_mcu7t5v0__clkbuf_2
XFILLER_79_422 VDD VDD VSS VSS gf180mcu_fd_sc_mcu7t5v0__fillcap_8
XFILLER_4_687 VDD VDD VSS VSS gf180mcu_fd_sc_mcu7t5v0__fill_2
XFILLER_3_164 VDD VDD VSS VSS gf180mcu_fd_sc_mcu7t5v0__fill_1
XTAP_TAPCELL_ROW_65_829 VDD VSS gf180mcu_fd_sc_mcu7t5v0__filltie
XFILLER_47_352 VDD VDD VSS VSS gf180mcu_fd_sc_mcu7t5v0__fillcap_32
XFILLER_74_171 VDD VDD VSS VSS gf180mcu_fd_sc_mcu7t5v0__fillcap_4
XFILLER_15_282 VDD VDD VSS VSS gf180mcu_fd_sc_mcu7t5v0__fill_2
XFILLER_30_241 VDD VDD VSS VSS gf180mcu_fd_sc_mcu7t5v0__fillcap_4
X_1823_ _1823_/I0 _2078_/Q _1823_/S _2078_/D VDD VDD VSS VSS gf180mcu_fd_sc_mcu7t5v0__mux2_2
X_1754_ _1829_/A3 _1754_/A2 _1754_/B1 _1314_/Z _1755_/A1 VDD VDD VSS VSS gf180mcu_fd_sc_mcu7t5v0__aoi22_1
Xwire390 wire390/I cfg_rx_startaddr_o[4] VDD VDD VSS VSS gf180mcu_fd_sc_mcu7t5v0__clkbuf_3
XFILLER_7_492 VDD VDD VSS VSS gf180mcu_fd_sc_mcu7t5v0__fillcap_32
X_1685_ _1685_/A1 _1446_/Z _2051_/Q _1686_/B VDD VDD VSS VSS gf180mcu_fd_sc_mcu7t5v0__nand3_1
XTAP_TAPCELL_ROW_88_1050 VDD VSS gf180mcu_fd_sc_mcu7t5v0__filltie
XFILLER_38_341 VDD VDD VSS VSS gf180mcu_fd_sc_mcu7t5v0__fill_2
X_2168_ _2168_/D _2169_/RN _2173_/CLK _2168_/Q VDD VDD VSS VSS gf180mcu_fd_sc_mcu7t5v0__dffrnq_1
XFILLER_93_480 VDD VDD VSS VSS gf180mcu_fd_sc_mcu7t5v0__fillcap_8
XFILLER_66_683 VDD VDD VSS VSS gf180mcu_fd_sc_mcu7t5v0__fillcap_8
X_2099_ _2099_/D _2174_/RN _2100_/CLK _2099_/Q VDD VDD VSS VSS gf180mcu_fd_sc_mcu7t5v0__dffrnq_1
X_1119_ _2092_/Q _2167_/Q _1119_/Z VDD VDD VSS VSS gf180mcu_fd_sc_mcu7t5v0__and2_1
XTAP_TAPCELL_ROW_36_553 VDD VSS gf180mcu_fd_sc_mcu7t5v0__filltie
XFILLER_81_664 VDD VDD VSS VSS gf180mcu_fd_sc_mcu7t5v0__fillcap_16
XPHY_EDGE_ROW_17_Right_17 VDD VSS gf180mcu_fd_sc_mcu7t5v0__endcap
XFILLER_79_26 VDD VDD VSS VSS gf180mcu_fd_sc_mcu7t5v0__fillcap_4
XFILLER_88_241 VDD VDD VSS VSS gf180mcu_fd_sc_mcu7t5v0__fillcap_4
XTAP_TAPCELL_ROW_8_289 VDD VSS gf180mcu_fd_sc_mcu7t5v0__filltie
XPHY_EDGE_ROW_26_Right_26 VDD VSS gf180mcu_fd_sc_mcu7t5v0__endcap
XFILLER_88_263 VDD VDD VSS VSS gf180mcu_fd_sc_mcu7t5v0__fillcap_8
XFILLER_76_403 VDD VDD VSS VSS gf180mcu_fd_sc_mcu7t5v0__fill_1
XFILLER_29_352 VDD VDD VSS VSS gf180mcu_fd_sc_mcu7t5v0__fillcap_8
XFILLER_91_417 VDD VDD VSS VSS gf180mcu_fd_sc_mcu7t5v0__fill_2
XFILLER_17_525 VDD VDD VSS VSS gf180mcu_fd_sc_mcu7t5v0__fill_1
XFILLER_29_374 VDD VDD VSS VSS gf180mcu_fd_sc_mcu7t5v0__fillcap_32
XFILLER_56_160 VDD VDD VSS VSS gf180mcu_fd_sc_mcu7t5v0__fill_1
XFILLER_71_163 VDD VDD VSS VSS gf180mcu_fd_sc_mcu7t5v0__fill_1
XFILLER_44_95 VDD VDD VSS VSS gf180mcu_fd_sc_mcu7t5v0__fillcap_8
XTAP_TAPCELL_ROW_70_876 VDD VSS gf180mcu_fd_sc_mcu7t5v0__filltie
XPHY_EDGE_ROW_35_Right_35 VDD VSS gf180mcu_fd_sc_mcu7t5v0__endcap
XFILLER_5_34 VDD VDD VSS VSS gf180mcu_fd_sc_mcu7t5v0__fillcap_16
X_1470_ _1946_/Q _1954_/Q _1472_/S _1470_/Z VDD VDD VSS VSS gf180mcu_fd_sc_mcu7t5v0__mux2_2
XFILLER_4_473 VDD VDD VSS VSS gf180mcu_fd_sc_mcu7t5v0__fill_2
XPHY_EDGE_ROW_44_Right_44 VDD VSS gf180mcu_fd_sc_mcu7t5v0__endcap
XFILLER_79_230 VDD VDD VSS VSS gf180mcu_fd_sc_mcu7t5v0__fillcap_4
XFILLER_0_690 VDD VDD VSS VSS gf180mcu_fd_sc_mcu7t5v0__fillcap_4
XTAP_TAPCELL_ROW_78_954 VDD VSS gf180mcu_fd_sc_mcu7t5v0__filltie
XFILLER_79_296 VDD VDD VSS VSS gf180mcu_fd_sc_mcu7t5v0__fill_1
X_2022_ _2022_/D _2028_/RN _2037_/CLK _2022_/Q VDD VDD VSS VSS gf180mcu_fd_sc_mcu7t5v0__dffrnq_1
XFILLER_35_344 VDD VDD VSS VSS gf180mcu_fd_sc_mcu7t5v0__fillcap_4
XFILLER_63_664 VDD VDD VSS VSS gf180mcu_fd_sc_mcu7t5v0__fillcap_16
XFILLER_62_141 VDD VDD VSS VSS gf180mcu_fd_sc_mcu7t5v0__fillcap_16
XFILLER_35_399 VDD VDD VSS VSS gf180mcu_fd_sc_mcu7t5v0__fillcap_16
XTAP_TAPCELL_ROW_33_523 VDD VSS gf180mcu_fd_sc_mcu7t5v0__filltie
XPHY_EDGE_ROW_53_Right_53 VDD VSS gf180mcu_fd_sc_mcu7t5v0__endcap
X_1806_ _1815_/C _1806_/A2 _1806_/A3 _1808_/A2 VDD VDD VSS VSS gf180mcu_fd_sc_mcu7t5v0__nand3_1
X_1737_ _1830_/A1 _2101_/Q _1740_/A3 VDD VDD VSS VSS gf180mcu_fd_sc_mcu7t5v0__nand2_1
X_1668_ _1670_/A1 _2038_/Q _1669_/A2 VDD VDD VSS VSS gf180mcu_fd_sc_mcu7t5v0__nand2_1
XPHY_EDGE_ROW_62_Right_62 VDD VSS gf180mcu_fd_sc_mcu7t5v0__endcap
X_1599_ _1973_/Q input27/Z _1600_/S _1973_/D VDD VDD VSS VSS gf180mcu_fd_sc_mcu7t5v0__mux2_2
Xclkbuf_5_24__f_periph_clk_i clkbuf_4_12_0_periph_clk_i/Z _2158_/CLK VDD VDD VSS VSS
+ gf180mcu_fd_sc_mcu7t5v0__clkbuf_16
XTAP_TAPCELL_ROW_5_259 VDD VSS gf180mcu_fd_sc_mcu7t5v0__filltie
XFILLER_66_480 VDD VDD VSS VSS gf180mcu_fd_sc_mcu7t5v0__fillcap_32
XFILLER_38_193 VDD VDD VSS VSS gf180mcu_fd_sc_mcu7t5v0__fillcap_8
XPHY_EDGE_ROW_71_Right_71 VDD VSS gf180mcu_fd_sc_mcu7t5v0__endcap
XFILLER_41_347 VDD VDD VSS VSS gf180mcu_fd_sc_mcu7t5v0__fill_2
XTAP_TAPCELL_ROW_97_1138 VDD VSS gf180mcu_fd_sc_mcu7t5v0__filltie
XFILLER_30_31 VDD VDD VSS VSS gf180mcu_fd_sc_mcu7t5v0__fillcap_4
XPHY_EDGE_ROW_80_Right_80 VDD VSS gf180mcu_fd_sc_mcu7t5v0__endcap
XFILLER_5_248 VDD VDD VSS VSS gf180mcu_fd_sc_mcu7t5v0__fill_1
XFILLER_49_403 VDD VDD VSS VSS gf180mcu_fd_sc_mcu7t5v0__fillcap_8
XFILLER_1_487 VDD VDD VSS VSS gf180mcu_fd_sc_mcu7t5v0__fill_2
XTAP_TAPCELL_ROW_75_924 VDD VSS gf180mcu_fd_sc_mcu7t5v0__filltie
XTAP_TAPCELL_ROW_47_659 VDD VSS gf180mcu_fd_sc_mcu7t5v0__filltie
X_0970_ _0982_/A1 _1319_/B _1673_/A3 VDD VDD VSS VSS gf180mcu_fd_sc_mcu7t5v0__nor2_1
XFILLER_60_667 VDD VDD VSS VSS gf180mcu_fd_sc_mcu7t5v0__fillcap_16
XFILLER_9_587 VDD VDD VSS VSS gf180mcu_fd_sc_mcu7t5v0__fill_2
X_1522_ _1524_/A1 _1925_/Q _1523_/B VDD VDD VSS VSS gf180mcu_fd_sc_mcu7t5v0__nand2_1
X_1453_ _1895_/Q _1894_/Q _1453_/S _1895_/D VDD VDD VSS VSS gf180mcu_fd_sc_mcu7t5v0__mux2_2
X_1384_ input82/Z _1395_/A2 _1396_/A2 input52/Z _1392_/B1 input94/Z _1385_/A2 VDD
+ VDD VSS VSS gf180mcu_fd_sc_mcu7t5v0__aoi222_1
XTAP_TAPCELL_ROW_2_229 VDD VSS gf180mcu_fd_sc_mcu7t5v0__filltie
XFILLER_95_553 VDD VDD VSS VSS gf180mcu_fd_sc_mcu7t5v0__fillcap_4
XFILLER_55_417 VDD VDD VSS VSS gf180mcu_fd_sc_mcu7t5v0__fill_2
X_2005_ _2005_/D _2034_/RN _2018_/CLK _2005_/Q VDD VDD VSS VSS gf180mcu_fd_sc_mcu7t5v0__dffrnq_1
XTAP_TAPCELL_ROW_85_1020 VDD VSS gf180mcu_fd_sc_mcu7t5v0__filltie
XFILLER_82_247 VDD VDD VSS VSS gf180mcu_fd_sc_mcu7t5v0__fillcap_8
XTAP_TAPCELL_ROW_18_383 VDD VSS gf180mcu_fd_sc_mcu7t5v0__filltie
XFILLER_50_122 VDD VDD VSS VSS gf180mcu_fd_sc_mcu7t5v0__fillcap_32
XFILLER_50_188 VDD VDD VSS VSS gf180mcu_fd_sc_mcu7t5v0__fillcap_16
XFILLER_76_16 VDD VDD VSS VSS gf180mcu_fd_sc_mcu7t5v0__fill_2
XFILLER_58_244 VDD VDD VSS VSS gf180mcu_fd_sc_mcu7t5v0__fill_1
XFILLER_86_597 VDD VDD VSS VSS gf180mcu_fd_sc_mcu7t5v0__fillcap_64
XFILLER_73_236 VDD VDD VSS VSS gf180mcu_fd_sc_mcu7t5v0__fill_1
XTAP_TAPCELL_ROW_44_629 VDD VSS gf180mcu_fd_sc_mcu7t5v0__filltie
XFILLER_92_37 VDD VDD VSS VSS gf180mcu_fd_sc_mcu7t5v0__fillcap_64
XFILLER_14_347 VDD VDD VSS VSS gf180mcu_fd_sc_mcu7t5v0__fill_1
XTAP_TAPCELL_ROW_80_971 VDD VSS gf180mcu_fd_sc_mcu7t5v0__filltie
XFILLER_42_667 VDD VDD VSS VSS gf180mcu_fd_sc_mcu7t5v0__fill_2
XFILLER_41_199 VDD VDD VSS VSS gf180mcu_fd_sc_mcu7t5v0__fillcap_8
XFILLER_41_52 VDD VDD VSS VSS gf180mcu_fd_sc_mcu7t5v0__fill_2
XFILLER_96_317 VDD VDD VSS VSS gf180mcu_fd_sc_mcu7t5v0__fillcap_8
XFILLER_1_284 VDD VDD VSS VSS gf180mcu_fd_sc_mcu7t5v0__fill_1
XFILLER_49_277 VDD VDD VSS VSS gf180mcu_fd_sc_mcu7t5v0__fill_2
XFILLER_64_247 VDD VDD VSS VSS gf180mcu_fd_sc_mcu7t5v0__fillcap_16
XFILLER_17_174 VDD VDD VSS VSS gf180mcu_fd_sc_mcu7t5v0__fillcap_4
XFILLER_32_122 VDD VDD VSS VSS gf180mcu_fd_sc_mcu7t5v0__fillcap_4
XFILLER_45_494 VDD VDD VSS VSS gf180mcu_fd_sc_mcu7t5v0__fill_1
XTAP_TAPCELL_ROW_15_353 VDD VSS gf180mcu_fd_sc_mcu7t5v0__filltie
XFILLER_20_317 VDD VDD VSS VSS gf180mcu_fd_sc_mcu7t5v0__fillcap_4
X_0953_ _2102_/Q _1739_/A1 VDD VDD VSS VSS gf180mcu_fd_sc_mcu7t5v0__clkinv_1
XFILLER_63_2 VDD VDD VSS VSS gf180mcu_fd_sc_mcu7t5v0__fillcap_64
Xoutput125 _1184_/Z wire305/I VDD VDD VSS VSS gf180mcu_fd_sc_mcu7t5v0__buf_1
Xoutput114 _1394_/ZN wire248/I VDD VDD VSS VSS gf180mcu_fd_sc_mcu7t5v0__buf_1
X_1505_ _1464_/Z _1915_/Q _1508_/S _1915_/D VDD VDD VSS VSS gf180mcu_fd_sc_mcu7t5v0__mux2_2
Xoutput158 _1994_/Q wire402/I VDD VDD VSS VSS gf180mcu_fd_sc_mcu7t5v0__buf_1
Xoutput147 _2117_/Q wire413/I VDD VDD VSS VSS gf180mcu_fd_sc_mcu7t5v0__buf_1
Xoutput136 _1194_/Z wire295/I VDD VDD VSS VSS gf180mcu_fd_sc_mcu7t5v0__buf_1
Xoutput169 _1981_/Q wire391/I VDD VDD VSS VSS gf180mcu_fd_sc_mcu7t5v0__buf_1
X_1436_ _2058_/Q _1882_/Q _1441_/S _1882_/D VDD VDD VSS VSS gf180mcu_fd_sc_mcu7t5v0__mux2_2
XFILLER_87_339 VDD VDD VSS VSS gf180mcu_fd_sc_mcu7t5v0__fillcap_8
X_1367_ _1376_/A1 _1329_/Z input67/Z _1376_/A2 _1368_/A2 VDD VDD VSS VSS gf180mcu_fd_sc_mcu7t5v0__nand4_1
XFILLER_68_564 VDD VDD VSS VSS gf180mcu_fd_sc_mcu7t5v0__fillcap_16
XFILLER_68_542 VDD VDD VSS VSS gf180mcu_fd_sc_mcu7t5v0__fillcap_4
XFILLER_68_597 VDD VDD VSS VSS gf180mcu_fd_sc_mcu7t5v0__fillcap_64
XFILLER_55_214 VDD VDD VSS VSS gf180mcu_fd_sc_mcu7t5v0__fill_1
X_1298_ _1304_/A1 _1298_/A2 _1303_/A3 _1304_/A4 _2174_/D VDD VDD VSS VSS gf180mcu_fd_sc_mcu7t5v0__and4_1
XFILLER_83_578 VDD VDD VSS VSS gf180mcu_fd_sc_mcu7t5v0__fill_1
XFILLER_70_239 VDD VDD VSS VSS gf180mcu_fd_sc_mcu7t5v0__fillcap_4
XFILLER_24_667 VDD VDD VSS VSS gf180mcu_fd_sc_mcu7t5v0__fill_2
XTAP_TAPCELL_ROW_94_1108 VDD VSS gf180mcu_fd_sc_mcu7t5v0__filltie
XFILLER_11_66 VDD VDD VSS VSS gf180mcu_fd_sc_mcu7t5v0__fillcap_4
XFILLER_78_317 VDD VDD VSS VSS gf180mcu_fd_sc_mcu7t5v0__fillcap_16
XFILLER_74_501 VDD VDD VSS VSS gf180mcu_fd_sc_mcu7t5v0__fill_1
XTAP_TAPCELL_ROW_57_754 VDD VSS gf180mcu_fd_sc_mcu7t5v0__filltie
XFILLER_46_225 VDD VDD VSS VSS gf180mcu_fd_sc_mcu7t5v0__fill_2
XFILLER_46_269 VDD VDD VSS VSS gf180mcu_fd_sc_mcu7t5v0__fill_2
XFILLER_14_111 VDD VDD VSS VSS gf180mcu_fd_sc_mcu7t5v0__fill_1
XFILLER_15_623 VDD VDD VSS VSS gf180mcu_fd_sc_mcu7t5v0__fillcap_4
XTAP_TAPCELL_ROW_29_489 VDD VSS gf180mcu_fd_sc_mcu7t5v0__filltie
XFILLER_61_228 VDD VDD VSS VSS gf180mcu_fd_sc_mcu7t5v0__fillcap_8
XTAP_TAPCELL_ROW_12_323 VDD VSS gf180mcu_fd_sc_mcu7t5v0__filltie
Xinput16 cfg_data_i[19] input16/Z VDD VDD VSS VSS gf180mcu_fd_sc_mcu7t5v0__dlyb_1
Xinput27 cfg_data_i[29] input27/Z VDD VDD VSS VSS gf180mcu_fd_sc_mcu7t5v0__dlyb_1
XFILLER_10_383 VDD VDD VSS VSS gf180mcu_fd_sc_mcu7t5v0__fill_2
Xinput38 cfg_rwn_i input38/Z VDD VDD VSS VSS gf180mcu_fd_sc_mcu7t5v0__dlyb_1
Xinput49 cfg_rx_bytes_left_i[4] input49/Z VDD VDD VSS VSS gf180mcu_fd_sc_mcu7t5v0__dlyb_1
XFILLER_6_387 VDD VDD VSS VSS gf180mcu_fd_sc_mcu7t5v0__fillcap_16
Xclkbuf_5_11__f_sys_clk_i clkbuf_4_5_0_sys_clk_i/Z clkload2/I VDD VDD VSS VSS gf180mcu_fd_sc_mcu7t5v0__clkbuf_16
XFILLER_97_626 VDD VDD VSS VSS gf180mcu_fd_sc_mcu7t5v0__fillcap_4
XFILLER_2_593 VDD VDD VSS VSS gf180mcu_fd_sc_mcu7t5v0__fill_2
X_1221_ _1211_/Z _1217_/Z _2138_/Q _1223_/A2 VDD VDD VSS VSS gf180mcu_fd_sc_mcu7t5v0__aoi21_1
XFILLER_84_309 VDD VDD VSS VSS gf180mcu_fd_sc_mcu7t5v0__fillcap_4
X_1152_ _1152_/A1 _2163_/Q _1281_/B _2095_/Q _1155_/A2 VDD VDD VSS VSS gf180mcu_fd_sc_mcu7t5v0__aoi22_1
X_1083_ _1250_/A1 _2159_/Q _1697_/B1 VDD VDD VSS VSS gf180mcu_fd_sc_mcu7t5v0__nand2_1
XFILLER_21_615 VDD VDD VSS VSS gf180mcu_fd_sc_mcu7t5v0__fill_2
XFILLER_33_475 VDD VDD VSS VSS gf180mcu_fd_sc_mcu7t5v0__fill_1
X_1985_ _1985_/D _2034_/RN _2018_/CLK _1985_/Q VDD VDD VSS VSS gf180mcu_fd_sc_mcu7t5v0__dffrnq_1
X_0936_ _2164_/Q _1259_/A1 VDD VDD VSS VSS gf180mcu_fd_sc_mcu7t5v0__clkinv_1
XFILLER_9_192 VDD VDD VSS VSS gf180mcu_fd_sc_mcu7t5v0__fill_2
XFILLER_87_136 VDD VDD VSS VSS gf180mcu_fd_sc_mcu7t5v0__fillcap_4
X_1419_ _2059_/Q _1867_/Q _1423_/S _1867_/D VDD VDD VSS VSS gf180mcu_fd_sc_mcu7t5v0__mux2_2
XFILLER_68_372 VDD VDD VSS VSS gf180mcu_fd_sc_mcu7t5v0__fill_2
XFILLER_83_364 VDD VDD VSS VSS gf180mcu_fd_sc_mcu7t5v0__fill_1
XTAP_TAPCELL_ROW_54_724 VDD VSS gf180mcu_fd_sc_mcu7t5v0__filltie
XFILLER_43_239 VDD VDD VSS VSS gf180mcu_fd_sc_mcu7t5v0__fillcap_32
XFILLER_43_228 VDD VDD VSS VSS gf180mcu_fd_sc_mcu7t5v0__fill_2
XTAP_TAPCELL_ROW_26_459 VDD VSS gf180mcu_fd_sc_mcu7t5v0__filltie
XFILLER_11_114 VDD VDD VSS VSS gf180mcu_fd_sc_mcu7t5v0__fill_2
XFILLER_98_36 VDD VDD VSS VSS gf180mcu_fd_sc_mcu7t5v0__fillcap_32
Xclkbuf_4_14_0_periph_clk_i clkbuf_0_periph_clk_i/Z clkbuf_4_14_0_periph_clk_i/Z VDD
+ VDD VSS VSS gf180mcu_fd_sc_mcu7t5v0__clkbuf_2
XFILLER_47_501 VDD VDD VSS VSS gf180mcu_fd_sc_mcu7t5v0__fill_1
XFILLER_87_692 VDD VDD VSS VSS gf180mcu_fd_sc_mcu7t5v0__fill_2
XFILLER_74_375 VDD VDD VSS VSS gf180mcu_fd_sc_mcu7t5v0__fillcap_8
XFILLER_47_84 VDD VDD VSS VSS gf180mcu_fd_sc_mcu7t5v0__fill_2
XFILLER_15_464 VDD VDD VSS VSS gf180mcu_fd_sc_mcu7t5v0__fillcap_8
XFILLER_63_72 VDD VDD VSS VSS gf180mcu_fd_sc_mcu7t5v0__fillcap_32
X_1770_ _2072_/Q _1823_/S _1777_/B VDD VDD VSS VSS gf180mcu_fd_sc_mcu7t5v0__nand2_1
XFILLER_8_34 VDD VDD VSS VSS gf180mcu_fd_sc_mcu7t5v0__fill_1
XFILLER_11_692 VDD VDD VSS VSS gf180mcu_fd_sc_mcu7t5v0__fill_2
XFILLER_97_445 VDD VDD VSS VSS gf180mcu_fd_sc_mcu7t5v0__fill_1
XFILLER_97_489 VDD VDD VSS VSS gf180mcu_fd_sc_mcu7t5v0__fill_1
XFILLER_85_629 VDD VDD VSS VSS gf180mcu_fd_sc_mcu7t5v0__fill_1
X_2184_ _2188_/Q _2193_/RN clkload6/I _2184_/Q VDD VDD VSS VSS gf180mcu_fd_sc_mcu7t5v0__dffrnq_1
X_1204_ _2132_/Q _1199_/Z _2133_/Q _1206_/A2 VDD VDD VSS VSS gf180mcu_fd_sc_mcu7t5v0__aoi21_1
XFILLER_38_523 VDD VDD VSS VSS gf180mcu_fd_sc_mcu7t5v0__fill_2
X_1135_ _1152_/A1 _2163_/Q _1156_/A1 _2097_/Q _1136_/A4 VDD VDD VSS VSS gf180mcu_fd_sc_mcu7t5v0__aoi22_1
X_1066_ _2096_/Q _2172_/Q _1067_/A2 VDD VDD VSS VSS gf180mcu_fd_sc_mcu7t5v0__nand2_1
XTAP_TAPCELL_ROW_23_429 VDD VSS gf180mcu_fd_sc_mcu7t5v0__filltie
XFILLER_80_378 VDD VDD VSS VSS gf180mcu_fd_sc_mcu7t5v0__fillcap_4
XFILLER_21_489 VDD VDD VSS VSS gf180mcu_fd_sc_mcu7t5v0__fill_1
X_1968_ _1968_/D _2092_/RN _1975_/CLK _1968_/Q VDD VDD VSS VSS gf180mcu_fd_sc_mcu7t5v0__dffrnq_1
X_1899_ _1899_/D _1918_/RN clkload5/I _1899_/Q VDD VDD VSS VSS gf180mcu_fd_sc_mcu7t5v0__dffrnq_1
X_0919_ _2088_/Q _1152_/A1 VDD VDD VSS VSS gf180mcu_fd_sc_mcu7t5v0__clkinv_1
XFILLER_88_489 VDD VDD VSS VSS gf180mcu_fd_sc_mcu7t5v0__fillcap_8
XFILLER_75_139 VDD VDD VSS VSS gf180mcu_fd_sc_mcu7t5v0__fill_1
XFILLER_69_692 VDD VDD VSS VSS gf180mcu_fd_sc_mcu7t5v0__fill_2
XFILLER_17_32 VDD VDD VSS VSS gf180mcu_fd_sc_mcu7t5v0__fillcap_32
XFILLER_16_228 VDD VDD VSS VSS gf180mcu_fd_sc_mcu7t5v0__fill_1
Xclkbuf_0_sys_clk_i sys_clk_i clkbuf_0_sys_clk_i/Z VDD VDD VSS VSS gf180mcu_fd_sc_mcu7t5v0__clkbuf_16
XTAP_TAPCELL_ROW_39_584 VDD VSS gf180mcu_fd_sc_mcu7t5v0__filltie
XFILLER_52_581 VDD VDD VSS VSS gf180mcu_fd_sc_mcu7t5v0__fillcap_8
XFILLER_12_423 VDD VDD VSS VSS gf180mcu_fd_sc_mcu7t5v0__fillcap_32
XFILLER_33_64 VDD VDD VSS VSS gf180mcu_fd_sc_mcu7t5v0__fillcap_4
Xudma_uart_top_501 data_rx_o[25] VDD VDD VSS VSS gf180mcu_fd_sc_mcu7t5v0__tiel
XFILLER_67_607 VDD VDD VSS VSS gf180mcu_fd_sc_mcu7t5v0__fillcap_16
XFILLER_79_489 VDD VDD VSS VSS gf180mcu_fd_sc_mcu7t5v0__fill_1
XFILLER_67_629 VDD VDD VSS VSS gf180mcu_fd_sc_mcu7t5v0__fill_1
XFILLER_94_437 VDD VDD VSS VSS gf180mcu_fd_sc_mcu7t5v0__fill_2
XFILLER_62_301 VDD VDD VSS VSS gf180mcu_fd_sc_mcu7t5v0__fillcap_8
XFILLER_74_93 VDD VDD VSS VSS gf180mcu_fd_sc_mcu7t5v0__fillcap_4
X_1822_ _1822_/A1 _1822_/A2 _1822_/B _1822_/C _1823_/I0 VDD VDD VSS VSS gf180mcu_fd_sc_mcu7t5v0__oai211_1
X_1753_ _1757_/A1 _1753_/A2 _1753_/B _1753_/C _2069_/D VDD VDD VSS VSS gf180mcu_fd_sc_mcu7t5v0__aoi211_1
X_1684_ _2050_/Q _1312_/Z _1684_/S _2050_/D VDD VDD VSS VSS gf180mcu_fd_sc_mcu7t5v0__mux2_2
Xwire380 wire380/I cfg_tx_size_o[10] VDD VDD VSS VSS gf180mcu_fd_sc_mcu7t5v0__clkbuf_3
Xwire391 wire391/I cfg_rx_startaddr_o[3] VDD VDD VSS VSS gf180mcu_fd_sc_mcu7t5v0__clkbuf_3
Xload_slew352 _1874_/RN _1887_/RN VDD VDD VSS VSS gf180mcu_fd_sc_mcu7t5v0__clkbuf_3
XFILLER_85_415 VDD VDD VSS VSS gf180mcu_fd_sc_mcu7t5v0__fillcap_4
XFILLER_97_297 VDD VDD VSS VSS gf180mcu_fd_sc_mcu7t5v0__fill_1
XTAP_TAPCELL_ROW_88_1051 VDD VSS gf180mcu_fd_sc_mcu7t5v0__filltie
X_2167_ _2167_/D _2169_/RN _2170_/CLK _2167_/Q VDD VDD VSS VSS gf180mcu_fd_sc_mcu7t5v0__dffrnq_1
XFILLER_93_492 VDD VDD VSS VSS gf180mcu_fd_sc_mcu7t5v0__fillcap_4
XFILLER_81_632 VDD VDD VSS VSS gf180mcu_fd_sc_mcu7t5v0__fillcap_16
XFILLER_65_172 VDD VDD VSS VSS gf180mcu_fd_sc_mcu7t5v0__fill_2
X_2098_ _2098_/D _2098_/RN _2100_/CLK _2098_/Q VDD VDD VSS VSS gf180mcu_fd_sc_mcu7t5v0__dffrnq_1
X_1118_ _1296_/A1 _2098_/Q _1147_/A4 VDD VDD VSS VSS gf180mcu_fd_sc_mcu7t5v0__nand2_1
XTAP_TAPCELL_ROW_36_554 VDD VSS gf180mcu_fd_sc_mcu7t5v0__filltie
X_1049_ _2155_/Q _1415_/A1 _2156_/D VDD VDD VSS VSS gf180mcu_fd_sc_mcu7t5v0__or2_1
XFILLER_21_297 VDD VDD VSS VSS gf180mcu_fd_sc_mcu7t5v0__fillcap_32
XFILLER_5_408 VDD VDD VSS VSS gf180mcu_fd_sc_mcu7t5v0__fillcap_8
XFILLER_76_459 VDD VDD VSS VSS gf180mcu_fd_sc_mcu7t5v0__fill_1
XFILLER_76_437 VDD VDD VSS VSS gf180mcu_fd_sc_mcu7t5v0__fillcap_4
XFILLER_48_139 VDD VDD VSS VSS gf180mcu_fd_sc_mcu7t5v0__fillcap_16
XFILLER_28_53 VDD VDD VSS VSS gf180mcu_fd_sc_mcu7t5v0__fillcap_16
XFILLER_29_364 VDD VDD VSS VSS gf180mcu_fd_sc_mcu7t5v0__fill_2
XFILLER_84_470 VDD VDD VSS VSS gf180mcu_fd_sc_mcu7t5v0__fillcap_4
XFILLER_17_559 VDD VDD VSS VSS gf180mcu_fd_sc_mcu7t5v0__fill_1
XFILLER_71_142 VDD VDD VSS VSS gf180mcu_fd_sc_mcu7t5v0__fillcap_8
XFILLER_25_570 VDD VDD VSS VSS gf180mcu_fd_sc_mcu7t5v0__fillcap_4
XFILLER_32_507 VDD VDD VSS VSS gf180mcu_fd_sc_mcu7t5v0__fill_1
XFILLER_71_175 VDD VDD VSS VSS gf180mcu_fd_sc_mcu7t5v0__fill_1
XFILLER_71_197 VDD VDD VSS VSS gf180mcu_fd_sc_mcu7t5v0__fill_1
XTAP_TAPCELL_ROW_70_877 VDD VSS gf180mcu_fd_sc_mcu7t5v0__filltie
XFILLER_79_220 VDD VDD VSS VSS gf180mcu_fd_sc_mcu7t5v0__fill_2
XFILLER_69_82 VDD VDD VSS VSS gf180mcu_fd_sc_mcu7t5v0__fill_1
XTAP_TAPCELL_ROW_78_955 VDD VSS gf180mcu_fd_sc_mcu7t5v0__filltie
XFILLER_67_448 VDD VDD VSS VSS gf180mcu_fd_sc_mcu7t5v0__fill_1
X_2021_ _2021_/D _2117_/RN _2021_/CLK _2021_/Q VDD VDD VSS VSS gf180mcu_fd_sc_mcu7t5v0__dffrnq_1
XPHY_EDGE_ROW_19_Left_118 VDD VSS gf180mcu_fd_sc_mcu7t5v0__endcap
XFILLER_48_651 VDD VDD VSS VSS gf180mcu_fd_sc_mcu7t5v0__fill_2
XFILLER_63_632 VDD VDD VSS VSS gf180mcu_fd_sc_mcu7t5v0__fillcap_32
XFILLER_47_150 VDD VDD VSS VSS gf180mcu_fd_sc_mcu7t5v0__fill_1
Xclkbuf_5_11__f_periph_clk_i clkbuf_4_5_0_periph_clk_i/Z _2154_/CLK VDD VDD VSS VSS
+ gf180mcu_fd_sc_mcu7t5v0__clkbuf_16
XFILLER_75_492 VDD VDD VSS VSS gf180mcu_fd_sc_mcu7t5v0__fill_2
XFILLER_16_592 VDD VDD VSS VSS gf180mcu_fd_sc_mcu7t5v0__fill_2
XTAP_TAPCELL_ROW_33_524 VDD VSS gf180mcu_fd_sc_mcu7t5v0__filltie
XFILLER_93_2 VDD VDD VSS VSS gf180mcu_fd_sc_mcu7t5v0__fillcap_64
XFILLER_31_540 VDD VDD VSS VSS gf180mcu_fd_sc_mcu7t5v0__fillcap_16
XFILLER_31_562 VDD VDD VSS VSS gf180mcu_fd_sc_mcu7t5v0__fill_1
XPHY_EDGE_ROW_28_Left_127 VDD VSS gf180mcu_fd_sc_mcu7t5v0__endcap
X_1805_ _1813_/A1 _1815_/B2 _1917_/Q _1806_/A3 VDD VDD VSS VSS gf180mcu_fd_sc_mcu7t5v0__nand3_1
X_1736_ _1736_/A1 _1736_/A2 _2067_/D VDD VDD VSS VSS gf180mcu_fd_sc_mcu7t5v0__nand2_1
X_1667_ _2103_/D input37/Z _1672_/S _2037_/D VDD VDD VSS VSS gf180mcu_fd_sc_mcu7t5v0__mux2_2
X_1598_ _1972_/Q input26/Z _1600_/S _1972_/D VDD VDD VSS VSS gf180mcu_fd_sc_mcu7t5v0__mux2_2
XPHY_EDGE_ROW_37_Left_136 VDD VSS gf180mcu_fd_sc_mcu7t5v0__endcap
XFILLER_85_212 VDD VDD VSS VSS gf180mcu_fd_sc_mcu7t5v0__fillcap_4
XFILLER_58_448 VDD VDD VSS VSS gf180mcu_fd_sc_mcu7t5v0__fillcap_4
XFILLER_53_142 VDD VDD VSS VSS gf180mcu_fd_sc_mcu7t5v0__fillcap_8
XPHY_EDGE_ROW_46_Left_145 VDD VSS gf180mcu_fd_sc_mcu7t5v0__endcap
XFILLER_5_205 VDD VDD VSS VSS gf180mcu_fd_sc_mcu7t5v0__fillcap_4
XFILLER_1_422 VDD VDD VSS VSS gf180mcu_fd_sc_mcu7t5v0__fillcap_4
XPHY_EDGE_ROW_55_Left_154 VDD VSS gf180mcu_fd_sc_mcu7t5v0__endcap
Xclkbuf_5_16__f_sys_clk_i clkbuf_4_8_0_sys_clk_i/Z _1952_/CLK VDD VDD VSS VSS gf180mcu_fd_sc_mcu7t5v0__clkbuf_16
XFILLER_89_562 VDD VDD VSS VSS gf180mcu_fd_sc_mcu7t5v0__fillcap_64
XFILLER_49_426 VDD VDD VSS VSS gf180mcu_fd_sc_mcu7t5v0__fill_2
XTAP_TAPCELL_ROW_75_925 VDD VSS gf180mcu_fd_sc_mcu7t5v0__filltie
XFILLER_72_440 VDD VDD VSS VSS gf180mcu_fd_sc_mcu7t5v0__fillcap_4
XFILLER_57_492 VDD VDD VSS VSS gf180mcu_fd_sc_mcu7t5v0__fill_2
XFILLER_55_51 VDD VDD VSS VSS gf180mcu_fd_sc_mcu7t5v0__fillcap_4
XFILLER_45_632 VDD VDD VSS VSS gf180mcu_fd_sc_mcu7t5v0__fill_1
XPHY_EDGE_ROW_64_Left_163 VDD VSS gf180mcu_fd_sc_mcu7t5v0__endcap
XFILLER_13_562 VDD VDD VSS VSS gf180mcu_fd_sc_mcu7t5v0__fill_2
XFILLER_9_500 VDD VDD VSS VSS gf180mcu_fd_sc_mcu7t5v0__fill_1
XFILLER_65_6 VDD VDD VSS VSS gf180mcu_fd_sc_mcu7t5v0__fill_2
X_1521_ _1521_/A1 _1521_/A2 _1521_/B _1924_/D VDD VDD VSS VSS gf180mcu_fd_sc_mcu7t5v0__oai21_1
XPHY_EDGE_ROW_73_Left_172 VDD VSS gf180mcu_fd_sc_mcu7t5v0__endcap
X_1452_ _1894_/Q _1893_/Q _1452_/S _1894_/D VDD VDD VSS VSS gf180mcu_fd_sc_mcu7t5v0__mux2_2
X_1383_ _2050_/Q _1325_/Z _1393_/B1 input64/Z _1385_/A1 VDD VDD VSS VSS gf180mcu_fd_sc_mcu7t5v0__aoi22_1
XFILLER_67_212 VDD VDD VSS VSS gf180mcu_fd_sc_mcu7t5v0__fillcap_16
X_2004_ _2004_/D _2034_/RN _2018_/CLK _2004_/Q VDD VDD VSS VSS gf180mcu_fd_sc_mcu7t5v0__dffrnq_1
XTAP_TAPCELL_ROW_85_1021 VDD VSS gf180mcu_fd_sc_mcu7t5v0__filltie
XFILLER_82_259 VDD VDD VSS VSS gf180mcu_fd_sc_mcu7t5v0__fill_2
XFILLER_35_142 VDD VDD VSS VSS gf180mcu_fd_sc_mcu7t5v0__fillcap_16
XFILLER_36_676 VDD VDD VSS VSS gf180mcu_fd_sc_mcu7t5v0__fill_2
XPHY_EDGE_ROW_82_Left_181 VDD VSS gf180mcu_fd_sc_mcu7t5v0__endcap
XTAP_TAPCELL_ROW_18_384 VDD VSS gf180mcu_fd_sc_mcu7t5v0__filltie
XPHY_EDGE_ROW_91_Left_190 VDD VSS gf180mcu_fd_sc_mcu7t5v0__endcap
X_1719_ _2159_/Q _2101_/Q _1722_/A2 VDD VDD VSS VSS gf180mcu_fd_sc_mcu7t5v0__nor2_1
XFILLER_58_234 VDD VDD VSS VSS gf180mcu_fd_sc_mcu7t5v0__fillcap_8
XFILLER_46_429 VDD VDD VSS VSS gf180mcu_fd_sc_mcu7t5v0__fillcap_8
XFILLER_39_492 VDD VDD VSS VSS gf180mcu_fd_sc_mcu7t5v0__fillcap_64
XFILLER_41_112 VDD VDD VSS VSS gf180mcu_fd_sc_mcu7t5v0__fillcap_4
XTAP_TAPCELL_ROW_80_972 VDD VSS gf180mcu_fd_sc_mcu7t5v0__filltie
XFILLER_10_565 VDD VDD VSS VSS gf180mcu_fd_sc_mcu7t5v0__fillcap_8
XFILLER_77_532 VDD VDD VSS VSS gf180mcu_fd_sc_mcu7t5v0__fill_2
XFILLER_49_212 VDD VDD VSS VSS gf180mcu_fd_sc_mcu7t5v0__fill_1
XFILLER_92_524 VDD VDD VSS VSS gf180mcu_fd_sc_mcu7t5v0__fill_1
XFILLER_17_120 VDD VDD VSS VSS gf180mcu_fd_sc_mcu7t5v0__fillcap_4
XFILLER_17_142 VDD VDD VSS VSS gf180mcu_fd_sc_mcu7t5v0__fillcap_32
X_0952_ _2101_/Q _1738_/A1 VDD VDD VSS VSS gf180mcu_fd_sc_mcu7t5v0__clkinv_1
XTAP_TAPCELL_ROW_15_354 VDD VSS gf180mcu_fd_sc_mcu7t5v0__filltie
XFILLER_13_392 VDD VDD VSS VSS gf180mcu_fd_sc_mcu7t5v0__fillcap_4
XFILLER_9_352 VDD VDD VSS VSS gf180mcu_fd_sc_mcu7t5v0__fill_2
Xoutput115 _1397_/ZN wire247/I VDD VDD VSS VSS gf180mcu_fd_sc_mcu7t5v0__buf_1
XFILLER_56_2 VDD VDD VSS VSS gf180mcu_fd_sc_mcu7t5v0__fillcap_16
X_1504_ _1462_/Z _1914_/Q _1508_/S _1914_/D VDD VDD VSS VSS gf180mcu_fd_sc_mcu7t5v0__mux2_2
Xoutput159 _1995_/Q wire401/I VDD VDD VSS VSS gf180mcu_fd_sc_mcu7t5v0__buf_1
Xoutput148 _1990_/Q wire412/I VDD VDD VSS VSS gf180mcu_fd_sc_mcu7t5v0__buf_1
Xoutput137 _1195_/Z wire294/I VDD VDD VSS VSS gf180mcu_fd_sc_mcu7t5v0__buf_1
Xoutput126 _1185_/Z wire304/I VDD VDD VSS VSS gf180mcu_fd_sc_mcu7t5v0__buf_1
X_1435_ _2057_/Q _1881_/Q _1435_/S _1881_/D VDD VDD VSS VSS gf180mcu_fd_sc_mcu7t5v0__mux2_2
XTAP_TAPCELL_ROW_91_1080 VDD VSS gf180mcu_fd_sc_mcu7t5v0__filltie
X_1366_ input97/Z _1376_/A2 _1373_/A3 _1329_/Z _1368_/A1 VDD VDD VSS VSS gf180mcu_fd_sc_mcu7t5v0__nand4_1
XFILLER_83_502 VDD VDD VSS VSS gf180mcu_fd_sc_mcu7t5v0__fillcap_16
X_1297_ _2168_/Q _1297_/A2 _1288_/Z _1300_/A4 _1303_/A3 VDD VDD VSS VSS gf180mcu_fd_sc_mcu7t5v0__nand4_1
XFILLER_36_451 VDD VDD VSS VSS gf180mcu_fd_sc_mcu7t5v0__fillcap_4
XFILLER_36_473 VDD VDD VSS VSS gf180mcu_fd_sc_mcu7t5v0__fillcap_4
XFILLER_23_156 VDD VDD VSS VSS gf180mcu_fd_sc_mcu7t5v0__fill_1
XTAP_TAPCELL_ROW_94_1109 VDD VSS gf180mcu_fd_sc_mcu7t5v0__filltie
Xfanout320 _1511_/B _1577_/A1 VDD VDD VSS VSS gf180mcu_fd_sc_mcu7t5v0__buf_1
Xfanout353 _1883_/RN _1873_/RN VDD VDD VSS VSS gf180mcu_fd_sc_mcu7t5v0__buf_1
XFILLER_19_429 VDD VDD VSS VSS gf180mcu_fd_sc_mcu7t5v0__fillcap_16
XFILLER_86_373 VDD VDD VSS VSS gf180mcu_fd_sc_mcu7t5v0__fillcap_8
XTAP_TAPCELL_ROW_57_755 VDD VSS gf180mcu_fd_sc_mcu7t5v0__filltie
XFILLER_14_101 VDD VDD VSS VSS gf180mcu_fd_sc_mcu7t5v0__fillcap_4
XFILLER_42_465 VDD VDD VSS VSS gf180mcu_fd_sc_mcu7t5v0__fillcap_4
XTAP_TAPCELL_ROW_12_324 VDD VSS gf180mcu_fd_sc_mcu7t5v0__filltie
Xinput17 cfg_data_i[1] input17/Z VDD VDD VSS VSS gf180mcu_fd_sc_mcu7t5v0__dlyb_1
Xinput28 cfg_data_i[2] input28/Z VDD VDD VSS VSS gf180mcu_fd_sc_mcu7t5v0__dlyb_1
XFILLER_52_96 VDD VDD VSS VSS gf180mcu_fd_sc_mcu7t5v0__fillcap_8
Xinput39 cfg_rx_bytes_left_i[0] input39/Z VDD VDD VSS VSS gf180mcu_fd_sc_mcu7t5v0__dlyb_1
XFILLER_2_561 VDD VDD VSS VSS gf180mcu_fd_sc_mcu7t5v0__fillcap_4
X_1220_ _1230_/A1 _1220_/A2 _1218_/Z _2137_/D VDD VDD VSS VSS gf180mcu_fd_sc_mcu7t5v0__nor3_1
X_1151_ _1151_/A1 _2166_/Q _1253_/A1 _2086_/Q _1155_/A1 VDD VDD VSS VSS gf180mcu_fd_sc_mcu7t5v0__aoi22_1
XFILLER_77_93 VDD VDD VSS VSS gf180mcu_fd_sc_mcu7t5v0__fillcap_16
XFILLER_77_373 VDD VDD VSS VSS gf180mcu_fd_sc_mcu7t5v0__fillcap_8
XFILLER_92_343 VDD VDD VSS VSS gf180mcu_fd_sc_mcu7t5v0__fill_1
XFILLER_65_557 VDD VDD VSS VSS gf180mcu_fd_sc_mcu7t5v0__fill_2
XFILLER_18_451 VDD VDD VSS VSS gf180mcu_fd_sc_mcu7t5v0__fillcap_4
X_1082_ _1733_/A4 _1703_/C _1691_/C _1700_/B VDD VDD VSS VSS gf180mcu_fd_sc_mcu7t5v0__nor3_1
XFILLER_18_495 VDD VDD VSS VSS gf180mcu_fd_sc_mcu7t5v0__fill_1
XFILLER_92_387 VDD VDD VSS VSS gf180mcu_fd_sc_mcu7t5v0__fillcap_8
XFILLER_20_115 VDD VDD VSS VSS gf180mcu_fd_sc_mcu7t5v0__fillcap_4
X_1984_ _1984_/D _2025_/RN _2024_/CLK _1984_/Q VDD VDD VSS VSS gf180mcu_fd_sc_mcu7t5v0__dffrnq_1
XFILLER_60_295 VDD VDD VSS VSS gf180mcu_fd_sc_mcu7t5v0__fillcap_4
X_0935_ _2163_/Q _1257_/A1 VDD VDD VSS VSS gf180mcu_fd_sc_mcu7t5v0__clkinv_1
X_1418_ _2058_/Q _1866_/Q _1423_/S _1866_/D VDD VDD VSS VSS gf180mcu_fd_sc_mcu7t5v0__mux2_2
X_1349_ _1349_/A1 _1349_/A2 _1349_/A3 _1349_/ZN VDD VDD VSS VSS gf180mcu_fd_sc_mcu7t5v0__nand3_1
XFILLER_68_384 VDD VDD VSS VSS gf180mcu_fd_sc_mcu7t5v0__fill_1
XFILLER_56_524 VDD VDD VSS VSS gf180mcu_fd_sc_mcu7t5v0__fill_1
Xclkbuf_5_4__f_sys_clk_i clkbuf_4_2_0_sys_clk_i/Z _2031_/CLK VDD VDD VSS VSS gf180mcu_fd_sc_mcu7t5v0__clkbuf_16
XFILLER_43_207 VDD VDD VSS VSS gf180mcu_fd_sc_mcu7t5v0__fill_2
XTAP_TAPCELL_ROW_54_725 VDD VSS gf180mcu_fd_sc_mcu7t5v0__filltie
XFILLER_24_454 VDD VDD VSS VSS gf180mcu_fd_sc_mcu7t5v0__fill_1
XFILLER_36_281 VDD VDD VSS VSS gf180mcu_fd_sc_mcu7t5v0__fillcap_32
XFILLER_11_104 VDD VDD VSS VSS gf180mcu_fd_sc_mcu7t5v0__fillcap_4
XFILLER_24_465 VDD VDD VSS VSS gf180mcu_fd_sc_mcu7t5v0__fill_1
XFILLER_24_487 VDD VDD VSS VSS gf180mcu_fd_sc_mcu7t5v0__fillcap_16
XFILLER_11_137 VDD VDD VSS VSS gf180mcu_fd_sc_mcu7t5v0__fill_2
XFILLER_78_104 VDD VDD VSS VSS gf180mcu_fd_sc_mcu7t5v0__fill_1
XFILLER_78_148 VDD VDD VSS VSS gf180mcu_fd_sc_mcu7t5v0__fillcap_4
XFILLER_19_204 VDD VDD VSS VSS gf180mcu_fd_sc_mcu7t5v0__fillcap_4
XFILLER_19_259 VDD VDD VSS VSS gf180mcu_fd_sc_mcu7t5v0__fillcap_16
XFILLER_74_387 VDD VDD VSS VSS gf180mcu_fd_sc_mcu7t5v0__fill_2
XFILLER_62_527 VDD VDD VSS VSS gf180mcu_fd_sc_mcu7t5v0__fill_1
XFILLER_15_432 VDD VDD VSS VSS gf180mcu_fd_sc_mcu7t5v0__fillcap_32
XFILLER_70_593 VDD VDD VSS VSS gf180mcu_fd_sc_mcu7t5v0__fill_2
XFILLER_30_457 VDD VDD VSS VSS gf180mcu_fd_sc_mcu7t5v0__fillcap_8
Xmax_cap317 _1523_/A1 _1525_/A1 VDD VDD VSS VSS gf180mcu_fd_sc_mcu7t5v0__dlyb_1
XFILLER_7_664 VDD VDD VSS VSS gf180mcu_fd_sc_mcu7t5v0__fillcap_8
Xmax_cap339 _1311_/S1 _1312_/S1 VDD VDD VSS VSS gf180mcu_fd_sc_mcu7t5v0__buf_1
X_1203_ _1230_/A1 _1201_/Z _1203_/A3 _2132_/D VDD VDD VSS VSS gf180mcu_fd_sc_mcu7t5v0__nor3_1
XFILLER_84_107 VDD VDD VSS VSS gf180mcu_fd_sc_mcu7t5v0__fillcap_64
X_2183_ _2185_/Q _2193_/RN _2189_/CLK _2187_/D VDD VDD VSS VSS gf180mcu_fd_sc_mcu7t5v0__dffrnq_1
XFILLER_78_693 VDD VDD VSS VSS gf180mcu_fd_sc_mcu7t5v0__fill_1
X_1134_ _1134_/A1 _2172_/Q _1257_/A1 _2088_/Q _1136_/A3 VDD VDD VSS VSS gf180mcu_fd_sc_mcu7t5v0__aoi22_1
XFILLER_25_218 VDD VDD VSS VSS gf180mcu_fd_sc_mcu7t5v0__fill_1
X_1065_ _2096_/Q _2172_/Q _1065_/Z VDD VDD VSS VSS gf180mcu_fd_sc_mcu7t5v0__or2_1
X_1967_ _1967_/D _2092_/RN clkload7/I _1967_/Q VDD VDD VSS VSS gf180mcu_fd_sc_mcu7t5v0__dffrnq_1
X_1898_ _1898_/D _1951_/RN _1951_/CLK _1898_/Q VDD VDD VSS VSS gf180mcu_fd_sc_mcu7t5v0__dffrnq_1
X_0918_ _2087_/Q _1138_/A1 VDD VDD VSS VSS gf180mcu_fd_sc_mcu7t5v0__clkinv_1
XFILLER_88_457 VDD VDD VSS VSS gf180mcu_fd_sc_mcu7t5v0__fillcap_32
XFILLER_76_608 VDD VDD VSS VSS gf180mcu_fd_sc_mcu7t5v0__fill_2
XTAP_TAPCELL_ROW_67_850 VDD VSS gf180mcu_fd_sc_mcu7t5v0__filltie
XFILLER_44_505 VDD VDD VSS VSS gf180mcu_fd_sc_mcu7t5v0__fillcap_16
XTAP_TAPCELL_ROW_39_585 VDD VSS gf180mcu_fd_sc_mcu7t5v0__filltie
XFILLER_71_324 VDD VDD VSS VSS gf180mcu_fd_sc_mcu7t5v0__fillcap_16
XFILLER_56_376 VDD VDD VSS VSS gf180mcu_fd_sc_mcu7t5v0__fill_1
XFILLER_44_527 VDD VDD VSS VSS gf180mcu_fd_sc_mcu7t5v0__fillcap_8
XFILLER_52_593 VDD VDD VSS VSS gf180mcu_fd_sc_mcu7t5v0__fill_2
XFILLER_12_457 VDD VDD VSS VSS gf180mcu_fd_sc_mcu7t5v0__fillcap_16
Xudma_uart_top_502 data_rx_o[26] VDD VDD VSS VSS gf180mcu_fd_sc_mcu7t5v0__tiel
XFILLER_4_667 VDD VDD VSS VSS gf180mcu_fd_sc_mcu7t5v0__fillcap_16
XFILLER_79_402 VDD VDD VSS VSS gf180mcu_fd_sc_mcu7t5v0__fill_2
XFILLER_4_689 VDD VDD VSS VSS gf180mcu_fd_sc_mcu7t5v0__fill_1
XFILLER_66_107 VDD VDD VSS VSS gf180mcu_fd_sc_mcu7t5v0__fill_2
XFILLER_62_313 VDD VDD VSS VSS gf180mcu_fd_sc_mcu7t5v0__fill_2
XFILLER_50_508 VDD VDD VSS VSS gf180mcu_fd_sc_mcu7t5v0__fillcap_16
XFILLER_15_284 VDD VDD VSS VSS gf180mcu_fd_sc_mcu7t5v0__fill_1
Xclkbuf_5_23__f_sys_clk_i clkbuf_4_11_0_sys_clk_i/Z clkload5/I VDD VDD VSS VSS gf180mcu_fd_sc_mcu7t5v0__clkbuf_16
XFILLER_43_593 VDD VDD VSS VSS gf180mcu_fd_sc_mcu7t5v0__fill_2
XFILLER_43_582 VDD VDD VSS VSS gf180mcu_fd_sc_mcu7t5v0__fill_2
X_1821_ _1903_/Q _1821_/A2 _1821_/B _1821_/C _1822_/C VDD VDD VSS VSS gf180mcu_fd_sc_mcu7t5v0__oai211_1
X_1752_ _1756_/A1 _1822_/B _1742_/B _1753_/B VDD VDD VSS VSS gf180mcu_fd_sc_mcu7t5v0__nor3_1
X_1683_ _2049_/Q _1311_/Z _1684_/S _2049_/D VDD VDD VSS VSS gf180mcu_fd_sc_mcu7t5v0__mux2_2
Xwire370 wire370/I cfg_tx_size_o[5] VDD VDD VSS VSS gf180mcu_fd_sc_mcu7t5v0__clkbuf_3
Xwire381 wire381/I cfg_tx_size_o[0] VDD VDD VSS VSS gf180mcu_fd_sc_mcu7t5v0__clkbuf_3
Xwire392 wire392/I cfg_rx_startaddr_o[2] VDD VDD VSS VSS gf180mcu_fd_sc_mcu7t5v0__clkbuf_3
XFILLER_97_276 VDD VDD VSS VSS gf180mcu_fd_sc_mcu7t5v0__fillcap_4
XFILLER_26_505 VDD VDD VSS VSS gf180mcu_fd_sc_mcu7t5v0__fillcap_4
X_2166_ _2166_/D _2169_/RN _2170_/CLK _2166_/Q VDD VDD VSS VSS gf180mcu_fd_sc_mcu7t5v0__dffrnq_1
XFILLER_66_663 VDD VDD VSS VSS gf180mcu_fd_sc_mcu7t5v0__fill_2
XFILLER_26_527 VDD VDD VSS VSS gf180mcu_fd_sc_mcu7t5v0__fill_1
X_1117_ _1151_/A1 _2166_/Q _1139_/A3 VDD VDD VSS VSS gf180mcu_fd_sc_mcu7t5v0__nand2_1
XTAP_TAPCELL_ROW_88_1052 VDD VSS gf180mcu_fd_sc_mcu7t5v0__filltie
XTAP_TAPCELL_ROW_64_820 VDD VSS gf180mcu_fd_sc_mcu7t5v0__filltie
XFILLER_38_387 VDD VDD VSS VSS gf180mcu_fd_sc_mcu7t5v0__fill_2
X_2097_ _2097_/D _2097_/RN _2100_/CLK _2097_/Q VDD VDD VSS VSS gf180mcu_fd_sc_mcu7t5v0__dffrnq_1
X_1048_ _1170_/B _2052_/Q _1415_/A1 VDD VDD VSS VSS gf180mcu_fd_sc_mcu7t5v0__nor2_1
XTAP_TAPCELL_ROW_36_555 VDD VSS gf180mcu_fd_sc_mcu7t5v0__filltie
XFILLER_81_688 VDD VDD VSS VSS gf180mcu_fd_sc_mcu7t5v0__fillcap_4
XPHY_EDGE_ROW_3_Right_3 VDD VSS gf180mcu_fd_sc_mcu7t5v0__endcap
XFILLER_1_626 VDD VDD VSS VSS gf180mcu_fd_sc_mcu7t5v0__fillcap_4
XFILLER_76_416 VDD VDD VSS VSS gf180mcu_fd_sc_mcu7t5v0__fill_1
XFILLER_48_107 VDD VDD VSS VSS gf180mcu_fd_sc_mcu7t5v0__fillcap_32
XFILLER_91_419 VDD VDD VSS VSS gf180mcu_fd_sc_mcu7t5v0__fill_1
XFILLER_72_622 VDD VDD VSS VSS gf180mcu_fd_sc_mcu7t5v0__fill_2
XFILLER_56_173 VDD VDD VSS VSS gf180mcu_fd_sc_mcu7t5v0__fill_2
XFILLER_44_313 VDD VDD VSS VSS gf180mcu_fd_sc_mcu7t5v0__fill_2
XFILLER_44_379 VDD VDD VSS VSS gf180mcu_fd_sc_mcu7t5v0__fillcap_4
XTAP_TAPCELL_ROW_70_878 VDD VSS gf180mcu_fd_sc_mcu7t5v0__filltie
XFILLER_40_574 VDD VDD VSS VSS gf180mcu_fd_sc_mcu7t5v0__fill_2
XFILLER_12_298 VDD VDD VSS VSS gf180mcu_fd_sc_mcu7t5v0__fill_2
XFILLER_69_50 VDD VDD VSS VSS gf180mcu_fd_sc_mcu7t5v0__fillcap_4
XFILLER_5_58 VDD VDD VSS VSS gf180mcu_fd_sc_mcu7t5v0__fillcap_4
XFILLER_4_475 VDD VDD VSS VSS gf180mcu_fd_sc_mcu7t5v0__fill_1
XFILLER_69_72 VDD VDD VSS VSS gf180mcu_fd_sc_mcu7t5v0__fillcap_8
XFILLER_79_276 VDD VDD VSS VSS gf180mcu_fd_sc_mcu7t5v0__fillcap_4
XTAP_TAPCELL_ROW_7_280 VDD VSS gf180mcu_fd_sc_mcu7t5v0__filltie
X_2020_ _2020_/D _2020_/RN _2020_/CLK _2020_/Q VDD VDD VSS VSS gf180mcu_fd_sc_mcu7t5v0__dffrnq_1
XTAP_TAPCELL_ROW_78_956 VDD VSS gf180mcu_fd_sc_mcu7t5v0__filltie
XFILLER_75_460 VDD VDD VSS VSS gf180mcu_fd_sc_mcu7t5v0__fillcap_16
XFILLER_90_430 VDD VDD VSS VSS gf180mcu_fd_sc_mcu7t5v0__fill_2
XFILLER_62_121 VDD VDD VSS VSS gf180mcu_fd_sc_mcu7t5v0__fillcap_4
XFILLER_63_688 VDD VDD VSS VSS gf180mcu_fd_sc_mcu7t5v0__fillcap_4
XFILLER_62_165 VDD VDD VSS VSS gf180mcu_fd_sc_mcu7t5v0__fillcap_8
XTAP_TAPCELL_ROW_33_525 VDD VSS gf180mcu_fd_sc_mcu7t5v0__filltie
Xclkbuf_4_2_0_periph_clk_i clkbuf_0_periph_clk_i/Z clkbuf_4_2_0_periph_clk_i/Z VDD
+ VDD VSS VSS gf180mcu_fd_sc_mcu7t5v0__clkbuf_2
XFILLER_86_2 VDD VDD VSS VSS gf180mcu_fd_sc_mcu7t5v0__fillcap_32
X_1804_ _1815_/A1 _1925_/Q _1806_/A2 VDD VDD VSS VSS gf180mcu_fd_sc_mcu7t5v0__nand2_1
X_1735_ _1735_/A1 _2067_/Q _1736_/A2 VDD VDD VSS VSS gf180mcu_fd_sc_mcu7t5v0__nand2_1
X_1666_ _2106_/D input36/Z _1672_/S _2036_/D VDD VDD VSS VSS gf180mcu_fd_sc_mcu7t5v0__mux2_2
X_1597_ _1971_/Q input25/Z _1601_/S _1971_/D VDD VDD VSS VSS gf180mcu_fd_sc_mcu7t5v0__mux2_2
XFILLER_85_268 VDD VDD VSS VSS gf180mcu_fd_sc_mcu7t5v0__fillcap_8
XFILLER_54_611 VDD VDD VSS VSS gf180mcu_fd_sc_mcu7t5v0__fillcap_8
XFILLER_38_173 VDD VDD VSS VSS gf180mcu_fd_sc_mcu7t5v0__fill_2
X_2149_ _2153_/Q fanout346/Z _2153_/CLK _2149_/Q VDD VDD VSS VSS gf180mcu_fd_sc_mcu7t5v0__dffsnq_1
XTAP_TAPCELL_ROW_49_680 VDD VSS gf180mcu_fd_sc_mcu7t5v0__filltie
XFILLER_81_430 VDD VDD VSS VSS gf180mcu_fd_sc_mcu7t5v0__fillcap_4
XFILLER_26_379 VDD VDD VSS VSS gf180mcu_fd_sc_mcu7t5v0__fillcap_4
XFILLER_53_154 VDD VDD VSS VSS gf180mcu_fd_sc_mcu7t5v0__fill_1
XFILLER_81_485 VDD VDD VSS VSS gf180mcu_fd_sc_mcu7t5v0__fillcap_4
XFILLER_53_176 VDD VDD VSS VSS gf180mcu_fd_sc_mcu7t5v0__fillcap_32
XFILLER_41_349 VDD VDD VSS VSS gf180mcu_fd_sc_mcu7t5v0__fill_1
XFILLER_1_489 VDD VDD VSS VSS gf180mcu_fd_sc_mcu7t5v0__fill_1
XTAP_TAPCELL_ROW_4_250 VDD VSS gf180mcu_fd_sc_mcu7t5v0__filltie
XTAP_TAPCELL_ROW_75_926 VDD VSS gf180mcu_fd_sc_mcu7t5v0__filltie
XFILLER_72_474 VDD VDD VSS VSS gf180mcu_fd_sc_mcu7t5v0__fillcap_4
XFILLER_72_496 VDD VDD VSS VSS gf180mcu_fd_sc_mcu7t5v0__fill_1
XFILLER_13_585 VDD VDD VSS VSS gf180mcu_fd_sc_mcu7t5v0__fillcap_32
X_1520_ _1524_/A1 _1924_/Q _1521_/B VDD VDD VSS VSS gf180mcu_fd_sc_mcu7t5v0__nand2_1
X_1451_ _1893_/Q _1892_/Q _1451_/S _1893_/D VDD VDD VSS VSS gf180mcu_fd_sc_mcu7t5v0__mux2_2
X_1382_ _1382_/A1 _1382_/A2 _1382_/ZN VDD VDD VSS VSS gf180mcu_fd_sc_mcu7t5v0__nand2_1
XFILLER_95_500 VDD VDD VSS VSS gf180mcu_fd_sc_mcu7t5v0__fill_2
XFILLER_67_202 VDD VDD VSS VSS gf180mcu_fd_sc_mcu7t5v0__fillcap_8
XFILLER_55_419 VDD VDD VSS VSS gf180mcu_fd_sc_mcu7t5v0__fill_1
X_2003_ _2003_/D _2032_/RN clkload0/I _2003_/Q VDD VDD VSS VSS gf180mcu_fd_sc_mcu7t5v0__dffrnq_1
XTAP_TAPCELL_ROW_85_1022 VDD VSS gf180mcu_fd_sc_mcu7t5v0__filltie
Xclkbuf_5_9__f_sys_clk_i clkbuf_4_4_0_sys_clk_i/Z clkload1/I VDD VDD VSS VSS gf180mcu_fd_sc_mcu7t5v0__clkbuf_16
XTAP_TAPCELL_ROW_46_650 VDD VSS gf180mcu_fd_sc_mcu7t5v0__filltie
XTAP_TAPCELL_ROW_18_385 VDD VSS gf180mcu_fd_sc_mcu7t5v0__filltie
X_1718_ _1718_/I0 _2061_/Q _1718_/S _2061_/D VDD VDD VSS VSS gf180mcu_fd_sc_mcu7t5v0__mux2_2
X_1649_ _2019_/Q input6/Z _1652_/S _2019_/D VDD VDD VSS VSS gf180mcu_fd_sc_mcu7t5v0__mux2_2
XFILLER_76_18 VDD VDD VSS VSS gf180mcu_fd_sc_mcu7t5v0__fill_1
XFILLER_86_555 VDD VDD VSS VSS gf180mcu_fd_sc_mcu7t5v0__fillcap_8
XFILLER_86_588 VDD VDD VSS VSS gf180mcu_fd_sc_mcu7t5v0__fillcap_4
XFILLER_58_279 VDD VDD VSS VSS gf180mcu_fd_sc_mcu7t5v0__fillcap_8
XFILLER_58_268 VDD VDD VSS VSS gf180mcu_fd_sc_mcu7t5v0__fill_2
XTAP_TAPCELL_ROW_1_220 VDD VSS gf180mcu_fd_sc_mcu7t5v0__filltie
XFILLER_81_282 VDD VDD VSS VSS gf180mcu_fd_sc_mcu7t5v0__fillcap_8
XFILLER_42_647 VDD VDD VSS VSS gf180mcu_fd_sc_mcu7t5v0__fill_2
XFILLER_41_157 VDD VDD VSS VSS gf180mcu_fd_sc_mcu7t5v0__fillcap_8
XFILLER_41_124 VDD VDD VSS VSS gf180mcu_fd_sc_mcu7t5v0__fillcap_4
XTAP_TAPCELL_ROW_80_973 VDD VSS gf180mcu_fd_sc_mcu7t5v0__filltie
XFILLER_41_54 VDD VDD VSS VSS gf180mcu_fd_sc_mcu7t5v0__fill_1
XFILLER_10_588 VDD VDD VSS VSS gf180mcu_fd_sc_mcu7t5v0__fill_1
XFILLER_2_26 VDD VDD VSS VSS gf180mcu_fd_sc_mcu7t5v0__fillcap_8
XFILLER_2_37 VDD VDD VSS VSS gf180mcu_fd_sc_mcu7t5v0__fillcap_8
XFILLER_37_419 VDD VDD VSS VSS gf180mcu_fd_sc_mcu7t5v0__fill_1
XFILLER_49_279 VDD VDD VSS VSS gf180mcu_fd_sc_mcu7t5v0__fill_1
XFILLER_57_290 VDD VDD VSS VSS gf180mcu_fd_sc_mcu7t5v0__fill_2
XFILLER_32_102 VDD VDD VSS VSS gf180mcu_fd_sc_mcu7t5v0__fill_2
XTAP_TAPCELL_ROW_43_620 VDD VSS gf180mcu_fd_sc_mcu7t5v0__filltie
X_0951_ _2105_/Q _1835_/B1 VDD VDD VSS VSS gf180mcu_fd_sc_mcu7t5v0__clkinv_1
XTAP_TAPCELL_ROW_15_355 VDD VSS gf180mcu_fd_sc_mcu7t5v0__filltie
XFILLER_9_397 VDD VDD VSS VSS gf180mcu_fd_sc_mcu7t5v0__fillcap_4
Xoutput116 _1399_/ZN wire246/I VDD VDD VSS VSS gf180mcu_fd_sc_mcu7t5v0__buf_1
X_1503_ _1460_/Z _1913_/Q _1509_/S _1913_/D VDD VDD VSS VSS gf180mcu_fd_sc_mcu7t5v0__mux2_2
Xoutput149 _2000_/Q wire411/I VDD VDD VSS VSS gf180mcu_fd_sc_mcu7t5v0__buf_1
Xoutput138 _1365_/ZN wire226/I VDD VDD VSS VSS gf180mcu_fd_sc_mcu7t5v0__buf_1
Xoutput127 _1186_/Z wire303/I VDD VDD VSS VSS gf180mcu_fd_sc_mcu7t5v0__buf_1
X_1434_ _2056_/Q _1880_/Q _1435_/S _1880_/D VDD VDD VSS VSS gf180mcu_fd_sc_mcu7t5v0__mux2_2
XTAP_TAPCELL_ROW_91_1081 VDD VSS gf180mcu_fd_sc_mcu7t5v0__filltie
XFILLER_68_500 VDD VDD VSS VSS gf180mcu_fd_sc_mcu7t5v0__fill_1
X_1365_ _1363_/Z _1365_/A2 _1365_/ZN VDD VDD VSS VSS gf180mcu_fd_sc_mcu7t5v0__nand2_1
XFILLER_95_352 VDD VDD VSS VSS gf180mcu_fd_sc_mcu7t5v0__fillcap_16
XFILLER_68_588 VDD VDD VSS VSS gf180mcu_fd_sc_mcu7t5v0__fillcap_4
X_1296_ _1296_/A1 _1296_/A2 _1300_/A4 VDD VDD VSS VSS gf180mcu_fd_sc_mcu7t5v0__nor2_1
XFILLER_24_636 VDD VDD VSS VSS gf180mcu_fd_sc_mcu7t5v0__fill_1
XFILLER_63_282 VDD VDD VSS VSS gf180mcu_fd_sc_mcu7t5v0__fillcap_32
XFILLER_51_422 VDD VDD VSS VSS gf180mcu_fd_sc_mcu7t5v0__fillcap_16
Xfanout310 _1855_/S fanout310/Z VDD VDD VSS VSS gf180mcu_fd_sc_mcu7t5v0__buf_1
Xfanout321 _1455_/ZN _1511_/B VDD VDD VSS VSS gf180mcu_fd_sc_mcu7t5v0__dlyb_1
Xfanout332 _1815_/C _1799_/C VDD VDD VSS VSS gf180mcu_fd_sc_mcu7t5v0__dlyb_1
Xfanout343 _1009_/ZN _1789_/A2 VDD VDD VSS VSS gf180mcu_fd_sc_mcu7t5v0__dlyb_1
XFILLER_59_544 VDD VDD VSS VSS gf180mcu_fd_sc_mcu7t5v0__fill_1
XFILLER_36_10 VDD VDD VSS VSS gf180mcu_fd_sc_mcu7t5v0__fill_2
XFILLER_74_536 VDD VDD VSS VSS gf180mcu_fd_sc_mcu7t5v0__fillcap_16
XTAP_TAPCELL_ROW_57_756 VDD VSS gf180mcu_fd_sc_mcu7t5v0__filltie
XFILLER_14_135 VDD VDD VSS VSS gf180mcu_fd_sc_mcu7t5v0__fillcap_4
XTAP_TAPCELL_ROW_12_325 VDD VSS gf180mcu_fd_sc_mcu7t5v0__filltie
Xclkbuf_5_28__f_sys_clk_i clkbuf_4_14_0_sys_clk_i/Z _1961_/CLK VDD VDD VSS VSS gf180mcu_fd_sc_mcu7t5v0__clkbuf_16
Xinput18 cfg_data_i[20] input18/Z VDD VDD VSS VSS gf180mcu_fd_sc_mcu7t5v0__dlyb_1
Xinput29 cfg_data_i[30] input29/Z VDD VDD VSS VSS gf180mcu_fd_sc_mcu7t5v0__dlyb_1
XFILLER_77_72 VDD VDD VSS VSS gf180mcu_fd_sc_mcu7t5v0__fillcap_8
XFILLER_37_205 VDD VDD VSS VSS gf180mcu_fd_sc_mcu7t5v0__fillcap_4
X_1150_ _1150_/A1 _1150_/A2 _1150_/A3 _1159_/A1 VDD VDD VSS VSS gf180mcu_fd_sc_mcu7t5v0__nor3_1
XFILLER_77_352 VDD VDD VSS VSS gf180mcu_fd_sc_mcu7t5v0__fillcap_4
XFILLER_92_333 VDD VDD VSS VSS gf180mcu_fd_sc_mcu7t5v0__fillcap_8
XFILLER_92_311 VDD VDD VSS VSS gf180mcu_fd_sc_mcu7t5v0__fillcap_4
XFILLER_77_385 VDD VDD VSS VSS gf180mcu_fd_sc_mcu7t5v0__fill_1
XFILLER_65_525 VDD VDD VSS VSS gf180mcu_fd_sc_mcu7t5v0__fillcap_8
X_1081_ _1081_/A1 _1081_/A2 _1251_/A1 VDD VDD VSS VSS gf180mcu_fd_sc_mcu7t5v0__nor2_1
XFILLER_33_422 VDD VDD VSS VSS gf180mcu_fd_sc_mcu7t5v0__fillcap_4
XTAP_TAPCELL_ROW_28_480 VDD VSS gf180mcu_fd_sc_mcu7t5v0__filltie
XFILLER_21_617 VDD VDD VSS VSS gf180mcu_fd_sc_mcu7t5v0__fill_1
XFILLER_33_488 VDD VDD VSS VSS gf180mcu_fd_sc_mcu7t5v0__fill_2
X_1983_ _1983_/D _2025_/RN _2018_/CLK _1983_/Q VDD VDD VSS VSS gf180mcu_fd_sc_mcu7t5v0__dffrnq_1
X_0934_ _2162_/Q _1253_/A2 VDD VDD VSS VSS gf180mcu_fd_sc_mcu7t5v0__clkinv_1
XFILLER_9_194 VDD VDD VSS VSS gf180mcu_fd_sc_mcu7t5v0__fill_1
X_1417_ _2057_/Q _1865_/Q _1421_/S _1865_/D VDD VDD VSS VSS gf180mcu_fd_sc_mcu7t5v0__mux2_2
Xclkbuf_5_30__f_sys_clk_i clkbuf_4_15_0_sys_clk_i/Z _1975_/CLK VDD VDD VSS VSS gf180mcu_fd_sc_mcu7t5v0__clkbuf_16
XFILLER_96_683 VDD VDD VSS VSS gf180mcu_fd_sc_mcu7t5v0__fill_2
XFILLER_96_661 VDD VDD VSS VSS gf180mcu_fd_sc_mcu7t5v0__fillcap_4
XFILLER_68_374 VDD VDD VSS VSS gf180mcu_fd_sc_mcu7t5v0__fill_1
XFILLER_56_514 VDD VDD VSS VSS gf180mcu_fd_sc_mcu7t5v0__fillcap_8
X_1348_ _1959_/Q _1179_/Z _1325_/Z _2043_/Q _1349_/A3 VDD VDD VSS VSS gf180mcu_fd_sc_mcu7t5v0__aoi22_1
X_1279_ _1294_/A1 _1279_/A2 _1279_/A3 _1294_/A4 _2169_/D VDD VDD VSS VSS gf180mcu_fd_sc_mcu7t5v0__and4_1
XTAP_TAPCELL_ROW_54_726 VDD VSS gf180mcu_fd_sc_mcu7t5v0__filltie
XFILLER_24_477 VDD VDD VSS VSS gf180mcu_fd_sc_mcu7t5v0__fill_2
XFILLER_20_650 VDD VDD VSS VSS gf180mcu_fd_sc_mcu7t5v0__fill_1
XFILLER_22_23 VDD VDD VSS VSS gf180mcu_fd_sc_mcu7t5v0__fillcap_8
XFILLER_79_606 VDD VDD VSS VSS gf180mcu_fd_sc_mcu7t5v0__fill_1
XFILLER_79_628 VDD VDD VSS VSS gf180mcu_fd_sc_mcu7t5v0__fill_2
XFILLER_59_330 VDD VDD VSS VSS gf180mcu_fd_sc_mcu7t5v0__fillcap_4
XFILLER_59_352 VDD VDD VSS VSS gf180mcu_fd_sc_mcu7t5v0__fillcap_64
XFILLER_19_227 VDD VDD VSS VSS gf180mcu_fd_sc_mcu7t5v0__fillcap_32
XFILLER_86_171 VDD VDD VSS VSS gf180mcu_fd_sc_mcu7t5v0__fillcap_4
XFILLER_74_311 VDD VDD VSS VSS gf180mcu_fd_sc_mcu7t5v0__fillcap_4
XFILLER_47_64 VDD VDD VSS VSS gf180mcu_fd_sc_mcu7t5v0__fillcap_4
XFILLER_47_86 VDD VDD VSS VSS gf180mcu_fd_sc_mcu7t5v0__fill_1
XFILLER_55_580 VDD VDD VSS VSS gf180mcu_fd_sc_mcu7t5v0__fill_1
XFILLER_27_282 VDD VDD VSS VSS gf180mcu_fd_sc_mcu7t5v0__fillcap_16
XFILLER_30_403 VDD VDD VSS VSS gf180mcu_fd_sc_mcu7t5v0__fill_2
XTAP_TAPCELL_ROW_25_450 VDD VSS gf180mcu_fd_sc_mcu7t5v0__filltie
XFILLER_42_263 VDD VDD VSS VSS gf180mcu_fd_sc_mcu7t5v0__fill_1
XFILLER_30_469 VDD VDD VSS VSS gf180mcu_fd_sc_mcu7t5v0__fill_2
XFILLER_8_69 VDD VDD VSS VSS gf180mcu_fd_sc_mcu7t5v0__fill_1
XFILLER_7_632 VDD VDD VSS VSS gf180mcu_fd_sc_mcu7t5v0__fillcap_32
Xclkbuf_4_9_0_sys_clk_i clkbuf_0_sys_clk_i/Z clkbuf_4_9_0_sys_clk_i/Z VDD VDD VSS
+ VSS gf180mcu_fd_sc_mcu7t5v0__clkbuf_2
XFILLER_7_676 VDD VDD VSS VSS gf180mcu_fd_sc_mcu7t5v0__fill_2
Xmax_cap329 _1289_/A2 _1297_/A2 VDD VDD VSS VSS gf180mcu_fd_sc_mcu7t5v0__dlyb_1
Xmax_cap318 _1521_/A1 _1523_/A1 VDD VDD VSS VSS gf180mcu_fd_sc_mcu7t5v0__dlyb_1
X_1202_ _2130_/Q _2131_/Q _2132_/Q _1203_/A3 VDD VDD VSS VSS gf180mcu_fd_sc_mcu7t5v0__aoi21_1
XFILLER_78_661 VDD VDD VSS VSS gf180mcu_fd_sc_mcu7t5v0__fillcap_4
X_2182_ _2182_/D _2182_/RN _2182_/CLK _2182_/Q VDD VDD VSS VSS gf180mcu_fd_sc_mcu7t5v0__dffrnq_1
XFILLER_78_683 VDD VDD VSS VSS gf180mcu_fd_sc_mcu7t5v0__fillcap_8
X_1133_ _1133_/A1 _1132_/Z _1136_/A2 VDD VDD VSS VSS gf180mcu_fd_sc_mcu7t5v0__nand2_1
XFILLER_93_664 VDD VDD VSS VSS gf180mcu_fd_sc_mcu7t5v0__fillcap_16
X_1064_ _1064_/I _2110_/D VDD VDD VSS VSS gf180mcu_fd_sc_mcu7t5v0__clkinv_1
XFILLER_53_517 VDD VDD VSS VSS gf180mcu_fd_sc_mcu7t5v0__fill_1
XFILLER_21_469 VDD VDD VSS VSS gf180mcu_fd_sc_mcu7t5v0__fillcap_16
X_1966_ _1966_/D _2092_/RN clkload7/I _1966_/Q VDD VDD VSS VSS gf180mcu_fd_sc_mcu7t5v0__dffrnq_1
X_0917_ _2086_/Q _1148_/A1 VDD VDD VSS VSS gf180mcu_fd_sc_mcu7t5v0__clkinv_1
X_1897_ _1897_/D _1954_/RN _1921_/CLK _1897_/Q VDD VDD VSS VSS gf180mcu_fd_sc_mcu7t5v0__dffrnq_1
XFILLER_88_436 VDD VDD VSS VSS gf180mcu_fd_sc_mcu7t5v0__fillcap_16
XTAP_TAPCELL_ROW_67_851 VDD VSS gf180mcu_fd_sc_mcu7t5v0__filltie
XFILLER_84_653 VDD VDD VSS VSS gf180mcu_fd_sc_mcu7t5v0__fillcap_8
XTAP_TAPCELL_ROW_39_586 VDD VSS gf180mcu_fd_sc_mcu7t5v0__filltie
XFILLER_24_241 VDD VDD VSS VSS gf180mcu_fd_sc_mcu7t5v0__fillcap_4
XTAP_TAPCELL_ROW_22_420 VDD VSS gf180mcu_fd_sc_mcu7t5v0__filltie
XFILLER_33_88 VDD VDD VSS VSS gf180mcu_fd_sc_mcu7t5v0__fillcap_4
Xudma_uart_top_503 data_rx_o[27] VDD VDD VSS VSS gf180mcu_fd_sc_mcu7t5v0__tiel
XFILLER_20_491 VDD VDD VSS VSS gf180mcu_fd_sc_mcu7t5v0__fillcap_8
XFILLER_79_469 VDD VDD VSS VSS gf180mcu_fd_sc_mcu7t5v0__fillcap_16
XFILLER_94_439 VDD VDD VSS VSS gf180mcu_fd_sc_mcu7t5v0__fill_1
XFILLER_75_664 VDD VDD VSS VSS gf180mcu_fd_sc_mcu7t5v0__fillcap_16
XFILLER_47_344 VDD VDD VSS VSS gf180mcu_fd_sc_mcu7t5v0__fillcap_4
XFILLER_74_163 VDD VDD VSS VSS gf180mcu_fd_sc_mcu7t5v0__fillcap_8
XFILLER_90_667 VDD VDD VSS VSS gf180mcu_fd_sc_mcu7t5v0__fillcap_16
XFILLER_74_185 VDD VDD VSS VSS gf180mcu_fd_sc_mcu7t5v0__fillcap_4
XFILLER_62_325 VDD VDD VSS VSS gf180mcu_fd_sc_mcu7t5v0__fill_1
XFILLER_30_255 VDD VDD VSS VSS gf180mcu_fd_sc_mcu7t5v0__fillcap_4
X_1820_ _1911_/Q _1820_/A2 _1821_/B VDD VDD VSS VSS gf180mcu_fd_sc_mcu7t5v0__or2_1
Xclkbuf_4_10_0_periph_clk_i clkbuf_0_periph_clk_i/Z clkbuf_4_10_0_periph_clk_i/Z VDD
+ VDD VSS VSS gf180mcu_fd_sc_mcu7t5v0__clkbuf_2
X_1751_ _2084_/Q _1829_/A3 _1832_/A3 _2068_/Q _1753_/A2 VDD VDD VSS VSS gf180mcu_fd_sc_mcu7t5v0__aoi22_1
Xwire360 wire360/I cfg_tx_startaddr_o[3] VDD VDD VSS VSS gf180mcu_fd_sc_mcu7t5v0__clkbuf_3
X_1682_ _2048_/Q _1310_/Z _1682_/S _2048_/D VDD VDD VSS VSS gf180mcu_fd_sc_mcu7t5v0__mux2_2
Xwire371 wire371/I cfg_tx_size_o[4] VDD VDD VSS VSS gf180mcu_fd_sc_mcu7t5v0__clkbuf_3
Xwire382 wire382/I cfg_tx_en_o VDD VDD VSS VSS gf180mcu_fd_sc_mcu7t5v0__clkbuf_3
Xwire393 wire393/I cfg_rx_startaddr_o[1] VDD VDD VSS VSS gf180mcu_fd_sc_mcu7t5v0__clkbuf_3
X_2165_ _2165_/D _2169_/RN _2173_/CLK _2165_/Q VDD VDD VSS VSS gf180mcu_fd_sc_mcu7t5v0__dffrnq_1
XFILLER_38_333 VDD VDD VSS VSS gf180mcu_fd_sc_mcu7t5v0__fillcap_8
X_1116_ _1141_/B2 _2173_/Q _1147_/A3 VDD VDD VSS VSS gf180mcu_fd_sc_mcu7t5v0__nand2_1
XTAP_TAPCELL_ROW_88_1053 VDD VSS gf180mcu_fd_sc_mcu7t5v0__filltie
XFILLER_38_377 VDD VDD VSS VSS gf180mcu_fd_sc_mcu7t5v0__fillcap_8
X_2096_ _2096_/D _2130_/RN _2130_/CLK _2096_/Q VDD VDD VSS VSS gf180mcu_fd_sc_mcu7t5v0__dffrnq_1
XTAP_TAPCELL_ROW_64_821 VDD VSS gf180mcu_fd_sc_mcu7t5v0__filltie
XFILLER_53_347 VDD VDD VSS VSS gf180mcu_fd_sc_mcu7t5v0__fill_2
X_1047_ _1733_/A4 _1161_/A1 _1691_/C _2160_/Q _1170_/B VDD VDD VSS VSS gf180mcu_fd_sc_mcu7t5v0__nand4_1
XTAP_TAPCELL_ROW_36_556 VDD VSS gf180mcu_fd_sc_mcu7t5v0__filltie
XFILLER_80_177 VDD VDD VSS VSS gf180mcu_fd_sc_mcu7t5v0__fillcap_64
X_1949_ _1949_/D _2190_/RN _1949_/CLK _1949_/Q VDD VDD VSS VSS gf180mcu_fd_sc_mcu7t5v0__dffrnq_1
XFILLER_79_18 VDD VDD VSS VSS gf180mcu_fd_sc_mcu7t5v0__fillcap_8
XFILLER_0_104 VDD VDD VSS VSS gf180mcu_fd_sc_mcu7t5v0__fill_2
XFILLER_57_664 VDD VDD VSS VSS gf180mcu_fd_sc_mcu7t5v0__fillcap_16
XFILLER_17_517 VDD VDD VSS VSS gf180mcu_fd_sc_mcu7t5v0__fill_1
XFILLER_84_461 VDD VDD VSS VSS gf180mcu_fd_sc_mcu7t5v0__fill_1
XFILLER_56_185 VDD VDD VSS VSS gf180mcu_fd_sc_mcu7t5v0__fill_2
XFILLER_72_667 VDD VDD VSS VSS gf180mcu_fd_sc_mcu7t5v0__fillcap_16
XFILLER_40_520 VDD VDD VSS VSS gf180mcu_fd_sc_mcu7t5v0__fillcap_4
XTAP_TAPCELL_ROW_70_879 VDD VSS gf180mcu_fd_sc_mcu7t5v0__filltie
XFILLER_40_597 VDD VDD VSS VSS gf180mcu_fd_sc_mcu7t5v0__fillcap_16
XFILLER_60_53 VDD VDD VSS VSS gf180mcu_fd_sc_mcu7t5v0__fill_2
XFILLER_4_454 VDD VDD VSS VSS gf180mcu_fd_sc_mcu7t5v0__fill_1
XFILLER_79_244 VDD VDD VSS VSS gf180mcu_fd_sc_mcu7t5v0__fillcap_32
XFILLER_0_682 VDD VDD VSS VSS gf180mcu_fd_sc_mcu7t5v0__fillcap_8
XTAP_TAPCELL_ROW_7_281 VDD VSS gf180mcu_fd_sc_mcu7t5v0__filltie
XTAP_TAPCELL_ROW_78_957 VDD VSS gf180mcu_fd_sc_mcu7t5v0__filltie
XPHY_EDGE_ROW_13_Right_13 VDD VSS gf180mcu_fd_sc_mcu7t5v0__endcap
XFILLER_94_247 VDD VDD VSS VSS gf180mcu_fd_sc_mcu7t5v0__fillcap_16
XFILLER_47_130 VDD VDD VSS VSS gf180mcu_fd_sc_mcu7t5v0__fillcap_8
XFILLER_85_72 VDD VDD VSS VSS gf180mcu_fd_sc_mcu7t5v0__fillcap_64
XFILLER_62_100 VDD VDD VSS VSS gf180mcu_fd_sc_mcu7t5v0__fillcap_4
XFILLER_16_594 VDD VDD VSS VSS gf180mcu_fd_sc_mcu7t5v0__fill_1
XTAP_TAPCELL_ROW_33_526 VDD VSS gf180mcu_fd_sc_mcu7t5v0__filltie
XFILLER_62_177 VDD VDD VSS VSS gf180mcu_fd_sc_mcu7t5v0__fillcap_32
X_1803_ _1826_/A1 _1313_/Z _2077_/Q _1811_/A4 _1809_/C VDD VDD VSS VSS gf180mcu_fd_sc_mcu7t5v0__nand4_1
XPHY_EDGE_ROW_22_Right_22 VDD VSS gf180mcu_fd_sc_mcu7t5v0__endcap
XFILLER_79_2 VDD VDD VSS VSS gf180mcu_fd_sc_mcu7t5v0__fillcap_16
X_1734_ _1700_/B _1734_/A2 _2160_/Q _1735_/A1 VDD VDD VSS VSS gf180mcu_fd_sc_mcu7t5v0__oai21_1
X_1665_ input6/Z _2035_/Q _1665_/S _2035_/D VDD VDD VSS VSS gf180mcu_fd_sc_mcu7t5v0__mux2_2
X_1596_ _1970_/Q input24/Z _1596_/S _1970_/D VDD VDD VSS VSS gf180mcu_fd_sc_mcu7t5v0__mux2_2
XFILLER_98_542 VDD VDD VSS VSS gf180mcu_fd_sc_mcu7t5v0__fill_2
XPHY_EDGE_ROW_31_Right_31 VDD VSS gf180mcu_fd_sc_mcu7t5v0__endcap
XFILLER_58_439 VDD VDD VSS VSS gf180mcu_fd_sc_mcu7t5v0__fill_1
XFILLER_38_141 VDD VDD VSS VSS gf180mcu_fd_sc_mcu7t5v0__fillcap_32
XFILLER_54_601 VDD VDD VSS VSS gf180mcu_fd_sc_mcu7t5v0__fill_1
XFILLER_26_314 VDD VDD VSS VSS gf180mcu_fd_sc_mcu7t5v0__fill_1
X_2148_ _2152_/Q _2151_/RN clkload2/I _2148_/Q VDD VDD VSS VSS gf180mcu_fd_sc_mcu7t5v0__dffsnq_1
XTAP_TAPCELL_ROW_49_681 VDD VSS gf180mcu_fd_sc_mcu7t5v0__filltie
XFILLER_53_122 VDD VDD VSS VSS gf180mcu_fd_sc_mcu7t5v0__fillcap_4
X_2079_ _2079_/D _2079_/RN _2142_/CLK _2079_/Q VDD VDD VSS VSS gf180mcu_fd_sc_mcu7t5v0__dffrnq_1
XFILLER_54_667 VDD VDD VSS VSS gf180mcu_fd_sc_mcu7t5v0__fillcap_16
XFILLER_41_306 VDD VDD VSS VSS gf180mcu_fd_sc_mcu7t5v0__fill_2
XPHY_EDGE_ROW_40_Right_40 VDD VSS gf180mcu_fd_sc_mcu7t5v0__endcap
XFILLER_22_597 VDD VDD VSS VSS gf180mcu_fd_sc_mcu7t5v0__fillcap_8
XFILLER_5_229 VDD VDD VSS VSS gf180mcu_fd_sc_mcu7t5v0__fill_2
XFILLER_49_428 VDD VDD VSS VSS gf180mcu_fd_sc_mcu7t5v0__fill_1
XTAP_TAPCELL_ROW_4_251 VDD VSS gf180mcu_fd_sc_mcu7t5v0__filltie
XFILLER_76_247 VDD VDD VSS VSS gf180mcu_fd_sc_mcu7t5v0__fillcap_16
XFILLER_39_76 VDD VDD VSS VSS gf180mcu_fd_sc_mcu7t5v0__fill_2
XTAP_TAPCELL_ROW_75_927 VDD VSS gf180mcu_fd_sc_mcu7t5v0__filltie
XFILLER_91_206 VDD VDD VSS VSS gf180mcu_fd_sc_mcu7t5v0__fillcap_4
XFILLER_57_461 VDD VDD VSS VSS gf180mcu_fd_sc_mcu7t5v0__fill_1
XFILLER_45_612 VDD VDD VSS VSS gf180mcu_fd_sc_mcu7t5v0__fill_2
XFILLER_17_336 VDD VDD VSS VSS gf180mcu_fd_sc_mcu7t5v0__fill_2
XFILLER_57_494 VDD VDD VSS VSS gf180mcu_fd_sc_mcu7t5v0__fill_1
XFILLER_44_144 VDD VDD VSS VSS gf180mcu_fd_sc_mcu7t5v0__fillcap_4
XFILLER_44_177 VDD VDD VSS VSS gf180mcu_fd_sc_mcu7t5v0__fillcap_16
XFILLER_9_557 VDD VDD VSS VSS gf180mcu_fd_sc_mcu7t5v0__fill_2
XFILLER_71_96 VDD VDD VSS VSS gf180mcu_fd_sc_mcu7t5v0__fill_1
XFILLER_65_8 VDD VDD VSS VSS gf180mcu_fd_sc_mcu7t5v0__fill_1
X_1450_ _1892_/Q _1895_/Q _1450_/S _1892_/D VDD VDD VSS VSS gf180mcu_fd_sc_mcu7t5v0__mux2_2
XFILLER_4_284 VDD VDD VSS VSS gf180mcu_fd_sc_mcu7t5v0__fill_2
XFILLER_4_262 VDD VDD VSS VSS gf180mcu_fd_sc_mcu7t5v0__fill_1
X_1381_ input81/Z _1395_/A2 _1396_/A2 input51/Z _1392_/B1 input93/Z _1382_/A2 VDD
+ VDD VSS VSS gf180mcu_fd_sc_mcu7t5v0__aoi222_1
XFILLER_48_461 VDD VDD VSS VSS gf180mcu_fd_sc_mcu7t5v0__fill_1
X_2002_ _2002_/D _2031_/RN _2031_/CLK _2002_/Q VDD VDD VSS VSS gf180mcu_fd_sc_mcu7t5v0__dffrnq_1
XTAP_TAPCELL_ROW_85_1023 VDD VSS gf180mcu_fd_sc_mcu7t5v0__filltie
XTAP_TAPCELL_ROW_46_651 VDD VSS gf180mcu_fd_sc_mcu7t5v0__filltie
XFILLER_63_442 VDD VDD VSS VSS gf180mcu_fd_sc_mcu7t5v0__fill_2
XFILLER_90_283 VDD VDD VSS VSS gf180mcu_fd_sc_mcu7t5v0__fill_2
XTAP_TAPCELL_ROW_18_386 VDD VSS gf180mcu_fd_sc_mcu7t5v0__filltie
XFILLER_50_158 VDD VDD VSS VSS gf180mcu_fd_sc_mcu7t5v0__fill_1
X_1717_ _1724_/A3 _2102_/Q _1717_/B _1718_/I0 VDD VDD VSS VSS gf180mcu_fd_sc_mcu7t5v0__oai21_1
X_1648_ _1648_/A1 _1648_/A2 _1328_/B _1648_/ZN VDD VDD VSS VSS gf180mcu_fd_sc_mcu7t5v0__nor3_1
X_1579_ _1957_/Q _1577_/Z _1582_/A1 VDD VDD VSS VSS gf180mcu_fd_sc_mcu7t5v0__nand2_1
XFILLER_86_523 VDD VDD VSS VSS gf180mcu_fd_sc_mcu7t5v0__fill_2
XFILLER_58_247 VDD VDD VSS VSS gf180mcu_fd_sc_mcu7t5v0__fillcap_4
XTAP_TAPCELL_ROW_1_221 VDD VSS gf180mcu_fd_sc_mcu7t5v0__filltie
XFILLER_14_317 VDD VDD VSS VSS gf180mcu_fd_sc_mcu7t5v0__fillcap_16
XFILLER_26_177 VDD VDD VSS VSS gf180mcu_fd_sc_mcu7t5v0__fillcap_16
XFILLER_41_136 VDD VDD VSS VSS gf180mcu_fd_sc_mcu7t5v0__fillcap_4
XTAP_TAPCELL_ROW_80_974 VDD VSS gf180mcu_fd_sc_mcu7t5v0__filltie
XFILLER_6_527 VDD VDD VSS VSS gf180mcu_fd_sc_mcu7t5v0__fillcap_4
XFILLER_9_2 VDD VDD VSS VSS gf180mcu_fd_sc_mcu7t5v0__fillcap_64
XFILLER_2_49 VDD VDD VSS VSS gf180mcu_fd_sc_mcu7t5v0__fill_2
XFILLER_32_114 VDD VDD VSS VSS gf180mcu_fd_sc_mcu7t5v0__fillcap_8
XTAP_TAPCELL_ROW_43_621 VDD VSS gf180mcu_fd_sc_mcu7t5v0__filltie
XFILLER_32_169 VDD VDD VSS VSS gf180mcu_fd_sc_mcu7t5v0__fillcap_4
X_0950_ _2194_/Q _1172_/A1 VDD VDD VSS VSS gf180mcu_fd_sc_mcu7t5v0__clkinv_1
XTAP_TAPCELL_ROW_15_356 VDD VSS gf180mcu_fd_sc_mcu7t5v0__filltie
X_1502_ _1458_/Z _1912_/Q _1509_/S _1912_/D VDD VDD VSS VSS gf180mcu_fd_sc_mcu7t5v0__mux2_2
Xoutput139 _1372_/ZN wire225/I VDD VDD VSS VSS gf180mcu_fd_sc_mcu7t5v0__buf_1
Xoutput128 _1187_/Z wire302/I VDD VDD VSS VSS gf180mcu_fd_sc_mcu7t5v0__buf_1
Xoutput117 _1401_/ZN wire245/I VDD VDD VSS VSS gf180mcu_fd_sc_mcu7t5v0__buf_1
X_1433_ _2153_/D _1054_/Z _1433_/B _2152_/D _1435_/S VDD VDD VSS VSS gf180mcu_fd_sc_mcu7t5v0__oai211_1
X_1364_ input60/Z _1393_/B1 _1392_/B1 input90/Z _1365_/A2 VDD VDD VSS VSS gf180mcu_fd_sc_mcu7t5v0__aoi22_1
X_1295_ _1296_/A2 _1295_/A2 _1298_/A2 VDD VDD VSS VSS gf180mcu_fd_sc_mcu7t5v0__nand2_1
XFILLER_48_280 VDD VDD VSS VSS gf180mcu_fd_sc_mcu7t5v0__fill_2
XFILLER_83_559 VDD VDD VSS VSS gf180mcu_fd_sc_mcu7t5v0__fill_1
XFILLER_23_136 VDD VDD VSS VSS gf180mcu_fd_sc_mcu7t5v0__fillcap_4
Xfanout322 _1395_/B1 _1392_/B1 VDD VDD VSS VSS gf180mcu_fd_sc_mcu7t5v0__dlya_1
Xfanout333 _1012_/ZN _1821_/A2 VDD VDD VSS VSS gf180mcu_fd_sc_mcu7t5v0__dlyb_1
Xfanout344 _1009_/ZN _1815_/B2 VDD VDD VSS VSS gf180mcu_fd_sc_mcu7t5v0__dlyb_1
XFILLER_59_578 VDD VDD VSS VSS gf180mcu_fd_sc_mcu7t5v0__fill_2
XTAP_TAPCELL_ROW_57_757 VDD VSS gf180mcu_fd_sc_mcu7t5v0__filltie
XTAP_TAPCELL_ROW_12_326 VDD VSS gf180mcu_fd_sc_mcu7t5v0__filltie
Xinput19 cfg_data_i[21] input19/Z VDD VDD VSS VSS gf180mcu_fd_sc_mcu7t5v0__dlyb_1
Xclkbuf_4_8_0_sys_clk_i clkbuf_0_sys_clk_i/Z clkbuf_4_8_0_sys_clk_i/Z VDD VDD VSS
+ VSS gf180mcu_fd_sc_mcu7t5v0__clkbuf_2
XFILLER_77_320 VDD VDD VSS VSS gf180mcu_fd_sc_mcu7t5v0__fillcap_8
XFILLER_77_84 VDD VDD VSS VSS gf180mcu_fd_sc_mcu7t5v0__fill_2
X_1080_ _1080_/A1 _1080_/A2 _1080_/A3 _1080_/A4 _1081_/A2 VDD VDD VSS VSS gf180mcu_fd_sc_mcu7t5v0__nand4_1
XFILLER_65_559 VDD VDD VSS VSS gf180mcu_fd_sc_mcu7t5v0__fill_1
XFILLER_93_72 VDD VDD VSS VSS gf180mcu_fd_sc_mcu7t5v0__fillcap_64
XFILLER_92_378 VDD VDD VSS VSS gf180mcu_fd_sc_mcu7t5v0__fillcap_4
XFILLER_80_518 VDD VDD VSS VSS gf180mcu_fd_sc_mcu7t5v0__fillcap_4
XFILLER_73_570 VDD VDD VSS VSS gf180mcu_fd_sc_mcu7t5v0__fillcap_4
XFILLER_52_209 VDD VDD VSS VSS gf180mcu_fd_sc_mcu7t5v0__fill_2
XFILLER_45_272 VDD VDD VSS VSS gf180mcu_fd_sc_mcu7t5v0__fillcap_8
XTAP_TAPCELL_ROW_28_481 VDD VSS gf180mcu_fd_sc_mcu7t5v0__filltie
XFILLER_60_231 VDD VDD VSS VSS gf180mcu_fd_sc_mcu7t5v0__fillcap_8
X_1982_ _1982_/D _2117_/RN _2025_/CLK _1982_/Q VDD VDD VSS VSS gf180mcu_fd_sc_mcu7t5v0__dffrnq_1
X_0933_ _2161_/Q _1253_/A1 VDD VDD VSS VSS gf180mcu_fd_sc_mcu7t5v0__clkinv_1
XTAP_TAPCELL_ROW_93_1100 VDD VSS gf180mcu_fd_sc_mcu7t5v0__filltie
X_1416_ _2056_/Q _1864_/Q _1416_/S _1864_/D VDD VDD VSS VSS gf180mcu_fd_sc_mcu7t5v0__mux2_2
X_1347_ _1347_/A1 _1347_/A2 _1347_/A3 _1349_/A2 VDD VDD VSS VSS gf180mcu_fd_sc_mcu7t5v0__nor3_1
XFILLER_28_217 VDD VDD VSS VSS gf180mcu_fd_sc_mcu7t5v0__fillcap_16
X_1278_ _2168_/Q _2169_/Q _1278_/A3 _1279_/A3 VDD VDD VSS VSS gf180mcu_fd_sc_mcu7t5v0__nand3_1
XTAP_TAPCELL_ROW_54_727 VDD VSS gf180mcu_fd_sc_mcu7t5v0__filltie
XFILLER_43_209 VDD VDD VSS VSS gf180mcu_fd_sc_mcu7t5v0__fill_1
XFILLER_11_139 VDD VDD VSS VSS gf180mcu_fd_sc_mcu7t5v0__fill_1
XFILLER_47_10 VDD VDD VSS VSS gf180mcu_fd_sc_mcu7t5v0__fillcap_4
XFILLER_47_559 VDD VDD VSS VSS gf180mcu_fd_sc_mcu7t5v0__fill_1
XFILLER_74_389 VDD VDD VSS VSS gf180mcu_fd_sc_mcu7t5v0__fill_1
XTAP_TAPCELL_ROW_25_451 VDD VSS gf180mcu_fd_sc_mcu7t5v0__filltie
XPHY_EDGE_ROW_69_Right_69 VDD VSS gf180mcu_fd_sc_mcu7t5v0__endcap
XFILLER_8_37 VDD VDD VSS VSS gf180mcu_fd_sc_mcu7t5v0__fillcap_32
Xmax_cap319 _1477_/B _1521_/A1 VDD VDD VSS VSS gf180mcu_fd_sc_mcu7t5v0__clkbuf_1
XPHY_EDGE_ROW_78_Right_78 VDD VSS gf180mcu_fd_sc_mcu7t5v0__endcap
XFILLER_97_426 VDD VDD VSS VSS gf180mcu_fd_sc_mcu7t5v0__fill_1
XFILLER_97_415 VDD VDD VSS VSS gf180mcu_fd_sc_mcu7t5v0__fillcap_4
XFILLER_2_382 VDD VDD VSS VSS gf180mcu_fd_sc_mcu7t5v0__fill_2
X_1201_ _2130_/Q _2131_/Q _2132_/Q _1201_/Z VDD VDD VSS VSS gf180mcu_fd_sc_mcu7t5v0__and3_1
X_2181_ _2181_/D _2185_/RN _2194_/CLK _2181_/Q VDD VDD VSS VSS gf180mcu_fd_sc_mcu7t5v0__dffrnq_1
XFILLER_93_632 VDD VDD VSS VSS gf180mcu_fd_sc_mcu7t5v0__fillcap_32
XFILLER_77_161 VDD VDD VSS VSS gf180mcu_fd_sc_mcu7t5v0__fill_1
X_1132_ _2095_/Q _2170_/Q _1132_/Z VDD VDD VSS VSS gf180mcu_fd_sc_mcu7t5v0__or2_1
XFILLER_65_345 VDD VDD VSS VSS gf180mcu_fd_sc_mcu7t5v0__fillcap_4
XFILLER_25_209 VDD VDD VSS VSS gf180mcu_fd_sc_mcu7t5v0__fill_1
X_1063_ _2053_/Q _1703_/C _1691_/C _1064_/I VDD VDD VSS VSS gf180mcu_fd_sc_mcu7t5v0__nor3_1
XFILLER_80_304 VDD VDD VSS VSS gf180mcu_fd_sc_mcu7t5v0__fill_2
XFILLER_46_570 VDD VDD VSS VSS gf180mcu_fd_sc_mcu7t5v0__fillcap_8
XFILLER_18_283 VDD VDD VSS VSS gf180mcu_fd_sc_mcu7t5v0__fill_2
XPHY_EDGE_ROW_87_Right_87 VDD VSS gf180mcu_fd_sc_mcu7t5v0__endcap
XFILLER_61_562 VDD VDD VSS VSS gf180mcu_fd_sc_mcu7t5v0__fillcap_64
XFILLER_21_448 VDD VDD VSS VSS gf180mcu_fd_sc_mcu7t5v0__fillcap_4
X_1965_ _1965_/D _2092_/RN clkload7/I _1965_/Q VDD VDD VSS VSS gf180mcu_fd_sc_mcu7t5v0__dffrnq_1
X_0916_ _2085_/Q _1076_/A1 VDD VDD VSS VSS gf180mcu_fd_sc_mcu7t5v0__clkinv_1
X_1896_ _1896_/D _1954_/RN _1955_/CLK _1896_/Q VDD VDD VSS VSS gf180mcu_fd_sc_mcu7t5v0__dffrnq_1
XPHY_EDGE_ROW_96_Right_96 VDD VSS gf180mcu_fd_sc_mcu7t5v0__endcap
XTAP_TAPCELL_ROW_67_852 VDD VSS gf180mcu_fd_sc_mcu7t5v0__filltie
XFILLER_83_142 VDD VDD VSS VSS gf180mcu_fd_sc_mcu7t5v0__fillcap_64
XFILLER_37_570 VDD VDD VSS VSS gf180mcu_fd_sc_mcu7t5v0__fillcap_4
XFILLER_71_315 VDD VDD VSS VSS gf180mcu_fd_sc_mcu7t5v0__fill_1
XFILLER_17_68 VDD VDD VSS VSS gf180mcu_fd_sc_mcu7t5v0__fill_2
XTAP_TAPCELL_ROW_39_587 VDD VSS gf180mcu_fd_sc_mcu7t5v0__filltie
XFILLER_71_348 VDD VDD VSS VSS gf180mcu_fd_sc_mcu7t5v0__fill_2
XTAP_TAPCELL_ROW_22_421 VDD VSS gf180mcu_fd_sc_mcu7t5v0__filltie
Xudma_uart_top_504 data_rx_o[28] VDD VDD VSS VSS gf180mcu_fd_sc_mcu7t5v0__tiel
XFILLER_3_124 VDD VDD VSS VSS gf180mcu_fd_sc_mcu7t5v0__fill_2
XFILLER_79_404 VDD VDD VSS VSS gf180mcu_fd_sc_mcu7t5v0__fill_1
XFILLER_75_610 VDD VDD VSS VSS gf180mcu_fd_sc_mcu7t5v0__fillcap_16
XFILLER_75_632 VDD VDD VSS VSS gf180mcu_fd_sc_mcu7t5v0__fillcap_32
XFILLER_28_592 VDD VDD VSS VSS gf180mcu_fd_sc_mcu7t5v0__fill_2
XFILLER_74_85 VDD VDD VSS VSS gf180mcu_fd_sc_mcu7t5v0__fillcap_8
XFILLER_43_562 VDD VDD VSS VSS gf180mcu_fd_sc_mcu7t5v0__fillcap_16
XFILLER_70_381 VDD VDD VSS VSS gf180mcu_fd_sc_mcu7t5v0__fillcap_4
XFILLER_43_595 VDD VDD VSS VSS gf180mcu_fd_sc_mcu7t5v0__fill_1
XFILLER_43_584 VDD VDD VSS VSS gf180mcu_fd_sc_mcu7t5v0__fill_1
X_1750_ _2070_/Q _1756_/A1 _1832_/A3 VDD VDD VSS VSS gf180mcu_fd_sc_mcu7t5v0__nor2_1
XFILLER_11_492 VDD VDD VSS VSS gf180mcu_fd_sc_mcu7t5v0__fillcap_8
X_1681_ _2047_/Q _1309_/Z _1681_/S _2047_/D VDD VDD VSS VSS gf180mcu_fd_sc_mcu7t5v0__mux2_2
Xwire361 wire361/I cfg_tx_startaddr_o[2] VDD VDD VSS VSS gf180mcu_fd_sc_mcu7t5v0__clkbuf_3
Xwire372 wire372/I cfg_tx_size_o[3] VDD VDD VSS VSS gf180mcu_fd_sc_mcu7t5v0__clkbuf_3
Xwire383 wire383/I cfg_tx_continuous_o VDD VDD VSS VSS gf180mcu_fd_sc_mcu7t5v0__clkbuf_3
Xwire394 wire394/I cfg_rx_startaddr_o[11] VDD VDD VSS VSS gf180mcu_fd_sc_mcu7t5v0__clkbuf_3
Xload_slew311 fanout310/Z _1848_/S VDD VDD VSS VSS gf180mcu_fd_sc_mcu7t5v0__buf_4
XFILLER_97_212 VDD VDD VSS VSS gf180mcu_fd_sc_mcu7t5v0__fillcap_64
XFILLER_3_680 VDD VDD VSS VSS gf180mcu_fd_sc_mcu7t5v0__fillcap_8
XFILLER_78_470 VDD VDD VSS VSS gf180mcu_fd_sc_mcu7t5v0__fill_2
X_2164_ _2164_/D _2174_/RN _2176_/CLK _2164_/Q VDD VDD VSS VSS gf180mcu_fd_sc_mcu7t5v0__dffrnq_1
XFILLER_65_131 VDD VDD VSS VSS gf180mcu_fd_sc_mcu7t5v0__fill_1
X_1115_ _2086_/Q _2161_/Q _1115_/Z VDD VDD VSS VSS gf180mcu_fd_sc_mcu7t5v0__xor2_1
XFILLER_65_142 VDD VDD VSS VSS gf180mcu_fd_sc_mcu7t5v0__fillcap_4
XFILLER_38_389 VDD VDD VSS VSS gf180mcu_fd_sc_mcu7t5v0__fill_1
XFILLER_19_570 VDD VDD VSS VSS gf180mcu_fd_sc_mcu7t5v0__fillcap_4
X_2095_ _2095_/D _2098_/RN _2095_/CLK _2095_/Q VDD VDD VSS VSS gf180mcu_fd_sc_mcu7t5v0__dffrnq_1
XTAP_TAPCELL_ROW_64_822 VDD VSS gf180mcu_fd_sc_mcu7t5v0__filltie
XFILLER_80_123 VDD VDD VSS VSS gf180mcu_fd_sc_mcu7t5v0__fillcap_4
X_1046_ _1733_/A4 _1161_/A1 _1691_/C _1163_/C VDD VDD VSS VSS gf180mcu_fd_sc_mcu7t5v0__nand3_1
XTAP_TAPCELL_ROW_36_557 VDD VSS gf180mcu_fd_sc_mcu7t5v0__filltie
XFILLER_80_167 VDD VDD VSS VSS gf180mcu_fd_sc_mcu7t5v0__fillcap_8
XFILLER_80_145 VDD VDD VSS VSS gf180mcu_fd_sc_mcu7t5v0__fill_1
XFILLER_21_212 VDD VDD VSS VSS gf180mcu_fd_sc_mcu7t5v0__fill_2
XFILLER_61_392 VDD VDD VSS VSS gf180mcu_fd_sc_mcu7t5v0__fillcap_16
X_1948_ _1948_/D _1948_/RN _1949_/CLK _1948_/Q VDD VDD VSS VSS gf180mcu_fd_sc_mcu7t5v0__dffrnq_1
X_1879_ _1879_/D _1886_/RN _1887_/CLK _1879_/Q VDD VDD VSS VSS gf180mcu_fd_sc_mcu7t5v0__dffrnq_1
XFILLER_76_429 VDD VDD VSS VSS gf180mcu_fd_sc_mcu7t5v0__fillcap_8
XFILLER_69_470 VDD VDD VSS VSS gf180mcu_fd_sc_mcu7t5v0__fillcap_8
XFILLER_69_492 VDD VDD VSS VSS gf180mcu_fd_sc_mcu7t5v0__fillcap_16
XFILLER_57_632 VDD VDD VSS VSS gf180mcu_fd_sc_mcu7t5v0__fillcap_32
XFILLER_84_451 VDD VDD VSS VSS gf180mcu_fd_sc_mcu7t5v0__fillcap_4
XFILLER_72_624 VDD VDD VSS VSS gf180mcu_fd_sc_mcu7t5v0__fill_1
XFILLER_25_540 VDD VDD VSS VSS gf180mcu_fd_sc_mcu7t5v0__fillcap_4
XFILLER_44_33 VDD VDD VSS VSS gf180mcu_fd_sc_mcu7t5v0__fill_2
XFILLER_8_227 VDD VDD VSS VSS gf180mcu_fd_sc_mcu7t5v0__fillcap_4
XFILLER_79_212 VDD VDD VSS VSS gf180mcu_fd_sc_mcu7t5v0__fillcap_8
XFILLER_79_234 VDD VDD VSS VSS gf180mcu_fd_sc_mcu7t5v0__fill_2
XTAP_TAPCELL_ROW_7_282 VDD VSS gf180mcu_fd_sc_mcu7t5v0__filltie
XTAP_TAPCELL_ROW_78_958 VDD VSS gf180mcu_fd_sc_mcu7t5v0__filltie
XFILLER_47_142 VDD VDD VSS VSS gf180mcu_fd_sc_mcu7t5v0__fillcap_8
XFILLER_75_484 VDD VDD VSS VSS gf180mcu_fd_sc_mcu7t5v0__fillcap_4
XFILLER_63_624 VDD VDD VSS VSS gf180mcu_fd_sc_mcu7t5v0__fillcap_4
XFILLER_35_348 VDD VDD VSS VSS gf180mcu_fd_sc_mcu7t5v0__fill_2
XFILLER_90_465 VDD VDD VSS VSS gf180mcu_fd_sc_mcu7t5v0__fill_2
XFILLER_90_454 VDD VDD VSS VSS gf180mcu_fd_sc_mcu7t5v0__fill_1
XTAP_TAPCELL_ROW_33_527 VDD VSS gf180mcu_fd_sc_mcu7t5v0__filltie
X_1802_ _2076_/Q _1810_/A2 _1809_/B VDD VDD VSS VSS gf180mcu_fd_sc_mcu7t5v0__nand2_1
X_1733_ _2160_/Q _1733_/A2 _1687_/Z _1733_/A4 _1736_/A1 VDD VDD VSS VSS gf180mcu_fd_sc_mcu7t5v0__nand4_1
XFILLER_7_282 VDD VDD VSS VSS gf180mcu_fd_sc_mcu7t5v0__fillcap_4
X_1664_ _2034_/Q input12/Z _1664_/S _2034_/D VDD VDD VSS VSS gf180mcu_fd_sc_mcu7t5v0__mux2_2
X_1595_ _1969_/Q input23/Z _1596_/S _1969_/D VDD VDD VSS VSS gf180mcu_fd_sc_mcu7t5v0__mux2_2
X_2147_ _2147_/D _2151_/RN clkload2/I _2147_/Q VDD VDD VSS VSS gf180mcu_fd_sc_mcu7t5v0__dffrnq_1
XTAP_TAPCELL_ROW_49_682 VDD VSS gf180mcu_fd_sc_mcu7t5v0__filltie
XFILLER_81_410 VDD VDD VSS VSS gf180mcu_fd_sc_mcu7t5v0__fillcap_8
X_2078_ _2078_/D _2139_/RN _2129_/CLK _2078_/Q VDD VDD VSS VSS gf180mcu_fd_sc_mcu7t5v0__dffsnq_1
XFILLER_54_657 VDD VDD VSS VSS gf180mcu_fd_sc_mcu7t5v0__fillcap_8
X_1029_ _2098_/Q _2143_/Q _1029_/Z VDD VDD VSS VSS gf180mcu_fd_sc_mcu7t5v0__xor2_1
XFILLER_22_543 VDD VDD VSS VSS gf180mcu_fd_sc_mcu7t5v0__fillcap_4
XPHY_EDGE_ROW_15_Left_114 VDD VSS gf180mcu_fd_sc_mcu7t5v0__endcap
XFILLER_30_24 VDD VDD VSS VSS gf180mcu_fd_sc_mcu7t5v0__fill_2
XFILLER_39_66 VDD VDD VSS VSS gf180mcu_fd_sc_mcu7t5v0__fillcap_4
XFILLER_29_142 VDD VDD VSS VSS gf180mcu_fd_sc_mcu7t5v0__fillcap_64
XTAP_TAPCELL_ROW_75_928 VDD VSS gf180mcu_fd_sc_mcu7t5v0__filltie
XTAP_TAPCELL_ROW_4_252 VDD VSS gf180mcu_fd_sc_mcu7t5v0__filltie
XPHY_EDGE_ROW_24_Left_123 VDD VSS gf180mcu_fd_sc_mcu7t5v0__endcap
XFILLER_57_451 VDD VDD VSS VSS gf180mcu_fd_sc_mcu7t5v0__fillcap_8
XFILLER_57_473 VDD VDD VSS VSS gf180mcu_fd_sc_mcu7t5v0__fillcap_16
XFILLER_72_432 VDD VDD VSS VSS gf180mcu_fd_sc_mcu7t5v0__fillcap_8
XFILLER_55_87 VDD VDD VSS VSS gf180mcu_fd_sc_mcu7t5v0__fill_2
XPHY_EDGE_ROW_33_Left_132 VDD VSS gf180mcu_fd_sc_mcu7t5v0__endcap
XFILLER_40_395 VDD VDD VSS VSS gf180mcu_fd_sc_mcu7t5v0__fillcap_4
XFILLER_40_384 VDD VDD VSS VSS gf180mcu_fd_sc_mcu7t5v0__fill_1
X_1380_ _2049_/Q _1325_/Z _1393_/B1 input63/Z _1382_/A1 VDD VDD VSS VSS gf180mcu_fd_sc_mcu7t5v0__aoi22_1
XFILLER_95_502 VDD VDD VSS VSS gf180mcu_fd_sc_mcu7t5v0__fill_1
XPHY_EDGE_ROW_42_Left_141 VDD VSS gf180mcu_fd_sc_mcu7t5v0__endcap
XFILLER_95_557 VDD VDD VSS VSS gf180mcu_fd_sc_mcu7t5v0__fill_2
XFILLER_67_248 VDD VDD VSS VSS gf180mcu_fd_sc_mcu7t5v0__fillcap_16
X_2001_ _2001_/D _2018_/RN _2034_/CLK _2001_/Q VDD VDD VSS VSS gf180mcu_fd_sc_mcu7t5v0__dffrnq_1
XTAP_TAPCELL_ROW_85_1024 VDD VSS gf180mcu_fd_sc_mcu7t5v0__filltie
XTAP_TAPCELL_ROW_46_652 VDD VSS gf180mcu_fd_sc_mcu7t5v0__filltie
XFILLER_63_487 VDD VDD VSS VSS gf180mcu_fd_sc_mcu7t5v0__fill_2
XFILLER_50_115 VDD VDD VSS VSS gf180mcu_fd_sc_mcu7t5v0__fill_2
XTAP_TAPCELL_ROW_18_387 VDD VSS gf180mcu_fd_sc_mcu7t5v0__filltie
XPHY_EDGE_ROW_51_Left_150 VDD VSS gf180mcu_fd_sc_mcu7t5v0__endcap
XFILLER_91_2 VDD VDD VSS VSS gf180mcu_fd_sc_mcu7t5v0__fillcap_64
Xclkbuf_5_7__f_periph_clk_i clkbuf_4_3_0_periph_clk_i/Z clkload9/I VDD VDD VSS VSS
+ gf180mcu_fd_sc_mcu7t5v0__clkbuf_16
XTAP_TAPCELL_ROW_96_1120 VDD VSS gf180mcu_fd_sc_mcu7t5v0__filltie
X_1716_ _2062_/Q _2102_/Q _1717_/B VDD VDD VSS VSS gf180mcu_fd_sc_mcu7t5v0__nand2_1
X_1647_ _2018_/Q input8/Z _1647_/S _2018_/D VDD VDD VSS VSS gf180mcu_fd_sc_mcu7t5v0__mux2_2
X_1578_ _1578_/A1 _1577_/Z _1956_/D VDD VDD VSS VSS gf180mcu_fd_sc_mcu7t5v0__xor2_1
XFILLER_27_602 VDD VDD VSS VSS gf180mcu_fd_sc_mcu7t5v0__fillcap_8
XTAP_TAPCELL_ROW_1_222 VDD VSS gf180mcu_fd_sc_mcu7t5v0__filltie
XFILLER_41_104 VDD VDD VSS VSS gf180mcu_fd_sc_mcu7t5v0__fillcap_8
XFILLER_25_68 VDD VDD VSS VSS gf180mcu_fd_sc_mcu7t5v0__fill_2
XTAP_TAPCELL_ROW_80_975 VDD VSS gf180mcu_fd_sc_mcu7t5v0__filltie
Xclkbuf_4_7_0_sys_clk_i clkbuf_0_sys_clk_i/Z clkbuf_4_7_0_sys_clk_i/Z VDD VDD VSS
+ VSS gf180mcu_fd_sc_mcu7t5v0__clkbuf_2
XTAP_TAPCELL_ROW_9_300 VDD VSS gf180mcu_fd_sc_mcu7t5v0__filltie
XFILLER_77_557 VDD VDD VSS VSS gf180mcu_fd_sc_mcu7t5v0__fill_2
XFILLER_77_524 VDD VDD VSS VSS gf180mcu_fd_sc_mcu7t5v0__fillcap_8
XFILLER_66_53 VDD VDD VSS VSS gf180mcu_fd_sc_mcu7t5v0__fillcap_4
XFILLER_92_527 VDD VDD VSS VSS gf180mcu_fd_sc_mcu7t5v0__fillcap_64
XFILLER_85_590 VDD VDD VSS VSS gf180mcu_fd_sc_mcu7t5v0__fill_1
XFILLER_45_432 VDD VDD VSS VSS gf180mcu_fd_sc_mcu7t5v0__fillcap_4
XFILLER_32_104 VDD VDD VSS VSS gf180mcu_fd_sc_mcu7t5v0__fill_1
XFILLER_45_465 VDD VDD VSS VSS gf180mcu_fd_sc_mcu7t5v0__fillcap_16
XFILLER_32_126 VDD VDD VSS VSS gf180mcu_fd_sc_mcu7t5v0__fill_1
XTAP_TAPCELL_ROW_43_622 VDD VSS gf180mcu_fd_sc_mcu7t5v0__filltie
XFILLER_13_340 VDD VDD VSS VSS gf180mcu_fd_sc_mcu7t5v0__fill_1
XTAP_TAPCELL_ROW_15_357 VDD VSS gf180mcu_fd_sc_mcu7t5v0__filltie
XFILLER_60_457 VDD VDD VSS VSS gf180mcu_fd_sc_mcu7t5v0__fillcap_64
XFILLER_13_384 VDD VDD VSS VSS gf180mcu_fd_sc_mcu7t5v0__fillcap_8
XFILLER_9_333 VDD VDD VSS VSS gf180mcu_fd_sc_mcu7t5v0__fill_2
X_1501_ _1511_/B _1501_/A2 _1501_/A3 _1474_/B _1509_/S VDD VDD VSS VSS gf180mcu_fd_sc_mcu7t5v0__nand4_2
Xoutput129 _1188_/Z wire301/I VDD VDD VSS VSS gf180mcu_fd_sc_mcu7t5v0__buf_1
Xoutput118 _1403_/ZN wire244/I VDD VDD VSS VSS gf180mcu_fd_sc_mcu7t5v0__buf_1
X_1432_ _1879_/Q _2063_/Q _1432_/S _1879_/D VDD VDD VSS VSS gf180mcu_fd_sc_mcu7t5v0__mux2_2
XFILLER_68_513 VDD VDD VSS VSS gf180mcu_fd_sc_mcu7t5v0__fillcap_4
X_1363_ _1363_/A1 _1363_/A2 _1363_/Z VDD VDD VSS VSS gf180mcu_fd_sc_mcu7t5v0__and2_1
XFILLER_95_310 VDD VDD VSS VSS gf180mcu_fd_sc_mcu7t5v0__fill_1
XFILLER_68_546 VDD VDD VSS VSS gf180mcu_fd_sc_mcu7t5v0__fill_2
X_1294_ _1294_/A1 _1294_/A2 _1295_/A2 _1294_/A4 _2173_/D VDD VDD VSS VSS gf180mcu_fd_sc_mcu7t5v0__and4_1
XFILLER_36_443 VDD VDD VSS VSS gf180mcu_fd_sc_mcu7t5v0__fillcap_8
XFILLER_76_590 VDD VDD VSS VSS gf180mcu_fd_sc_mcu7t5v0__fillcap_4
XFILLER_48_292 VDD VDD VSS VSS gf180mcu_fd_sc_mcu7t5v0__fillcap_16
XFILLER_63_262 VDD VDD VSS VSS gf180mcu_fd_sc_mcu7t5v0__fillcap_4
XFILLER_51_413 VDD VDD VSS VSS gf180mcu_fd_sc_mcu7t5v0__fillcap_4
XFILLER_51_446 VDD VDD VSS VSS gf180mcu_fd_sc_mcu7t5v0__fill_2
Xfanout312 _1855_/S _1847_/S VDD VDD VSS VSS gf180mcu_fd_sc_mcu7t5v0__buf_1
Xfanout323 _1333_/Z _1396_/A2 VDD VDD VSS VSS gf180mcu_fd_sc_mcu7t5v0__dlya_1
Xfanout334 _1012_/ZN _1815_/A1 VDD VDD VSS VSS gf180mcu_fd_sc_mcu7t5v0__dlyb_1
XFILLER_59_524 VDD VDD VSS VSS gf180mcu_fd_sc_mcu7t5v0__fillcap_16
XFILLER_27_410 VDD VDD VSS VSS gf180mcu_fd_sc_mcu7t5v0__fill_2
XFILLER_36_12 VDD VDD VSS VSS gf180mcu_fd_sc_mcu7t5v0__fill_1
XFILLER_86_387 VDD VDD VSS VSS gf180mcu_fd_sc_mcu7t5v0__fillcap_16
XFILLER_39_270 VDD VDD VSS VSS gf180mcu_fd_sc_mcu7t5v0__fillcap_8
XFILLER_36_34 VDD VDD VSS VSS gf180mcu_fd_sc_mcu7t5v0__fill_1
XTAP_TAPCELL_ROW_57_758 VDD VSS gf180mcu_fd_sc_mcu7t5v0__filltie
XFILLER_15_627 VDD VDD VSS VSS gf180mcu_fd_sc_mcu7t5v0__fill_2
XFILLER_36_89 VDD VDD VSS VSS gf180mcu_fd_sc_mcu7t5v0__fillcap_16
XFILLER_82_593 VDD VDD VSS VSS gf180mcu_fd_sc_mcu7t5v0__fill_2
XFILLER_42_457 VDD VDD VSS VSS gf180mcu_fd_sc_mcu7t5v0__fillcap_8
XFILLER_10_310 VDD VDD VSS VSS gf180mcu_fd_sc_mcu7t5v0__fillcap_4
XTAP_TAPCELL_ROW_12_327 VDD VSS gf180mcu_fd_sc_mcu7t5v0__filltie
XFILLER_10_387 VDD VDD VSS VSS gf180mcu_fd_sc_mcu7t5v0__fill_2
XFILLER_10_398 VDD VDD VSS VSS gf180mcu_fd_sc_mcu7t5v0__fillcap_8
XFILLER_96_107 VDD VDD VSS VSS gf180mcu_fd_sc_mcu7t5v0__fillcap_64
XFILLER_2_597 VDD VDD VSS VSS gf180mcu_fd_sc_mcu7t5v0__fillcap_64
XFILLER_77_52 VDD VDD VSS VSS gf180mcu_fd_sc_mcu7t5v0__fill_2
XFILLER_77_332 VDD VDD VSS VSS gf180mcu_fd_sc_mcu7t5v0__fill_2
XFILLER_65_516 VDD VDD VSS VSS gf180mcu_fd_sc_mcu7t5v0__fillcap_4
XFILLER_65_549 VDD VDD VSS VSS gf180mcu_fd_sc_mcu7t5v0__fillcap_8
XTAP_TAPCELL_ROW_28_482 VDD VSS gf180mcu_fd_sc_mcu7t5v0__filltie
XFILLER_60_243 VDD VDD VSS VSS gf180mcu_fd_sc_mcu7t5v0__fill_2
XFILLER_20_107 VDD VDD VSS VSS gf180mcu_fd_sc_mcu7t5v0__fillcap_8
X_1981_ _1981_/D _2025_/RN _2024_/CLK _1981_/Q VDD VDD VSS VSS gf180mcu_fd_sc_mcu7t5v0__dffrnq_1
X_0932_ _2158_/Q _1250_/A1 VDD VDD VSS VSS gf180mcu_fd_sc_mcu7t5v0__clkinv_1
XFILLER_54_2 VDD VDD VSS VSS gf180mcu_fd_sc_mcu7t5v0__fill_1
X_1415_ _1415_/A1 _1054_/Z _1415_/A3 _1415_/A4 _1416_/S VDD VDD VSS VSS gf180mcu_fd_sc_mcu7t5v0__nand4_1
X_1346_ _1346_/A1 _1346_/A2 _1346_/A3 _1347_/A3 VDD VDD VSS VSS gf180mcu_fd_sc_mcu7t5v0__nand3_1
XFILLER_96_685 VDD VDD VSS VSS gf180mcu_fd_sc_mcu7t5v0__fill_1
XFILLER_83_313 VDD VDD VSS VSS gf180mcu_fd_sc_mcu7t5v0__fill_2
XFILLER_56_527 VDD VDD VSS VSS gf180mcu_fd_sc_mcu7t5v0__fillcap_64
X_1277_ _1281_/A1 _1281_/A2 _1279_/A2 VDD VDD VSS VSS gf180mcu_fd_sc_mcu7t5v0__nand2_1
XTAP_TAPCELL_ROW_54_728 VDD VSS gf180mcu_fd_sc_mcu7t5v0__filltie
XFILLER_64_571 VDD VDD VSS VSS gf180mcu_fd_sc_mcu7t5v0__fillcap_16
XFILLER_24_435 VDD VDD VSS VSS gf180mcu_fd_sc_mcu7t5v0__fillcap_4
XFILLER_24_446 VDD VDD VSS VSS gf180mcu_fd_sc_mcu7t5v0__fillcap_8
XFILLER_24_457 VDD VDD VSS VSS gf180mcu_fd_sc_mcu7t5v0__fillcap_8
XFILLER_51_298 VDD VDD VSS VSS gf180mcu_fd_sc_mcu7t5v0__fillcap_8
XFILLER_20_630 VDD VDD VSS VSS gf180mcu_fd_sc_mcu7t5v0__fillcap_16
XFILLER_78_107 VDD VDD VSS VSS gf180mcu_fd_sc_mcu7t5v0__fillcap_4
XFILLER_47_538 VDD VDD VSS VSS gf180mcu_fd_sc_mcu7t5v0__fillcap_4
XFILLER_15_402 VDD VDD VSS VSS gf180mcu_fd_sc_mcu7t5v0__fillcap_8
XTAP_TAPCELL_ROW_25_452 VDD VSS gf180mcu_fd_sc_mcu7t5v0__filltie
XPHY_EDGE_ROW_7_Left_106 VDD VSS gf180mcu_fd_sc_mcu7t5v0__endcap
XFILLER_42_298 VDD VDD VSS VSS gf180mcu_fd_sc_mcu7t5v0__fillcap_16
XFILLER_6_111 VDD VDD VSS VSS gf180mcu_fd_sc_mcu7t5v0__fill_1
X_2180_ _2180_/D _2182_/RN _2194_/CLK _2180_/Q VDD VDD VSS VSS gf180mcu_fd_sc_mcu7t5v0__dffrnq_1
X_1200_ _1230_/A1 _1200_/A2 _1199_/Z _2131_/D VDD VDD VSS VSS gf180mcu_fd_sc_mcu7t5v0__nor3_1
XFILLER_77_173 VDD VDD VSS VSS gf180mcu_fd_sc_mcu7t5v0__fill_2
XFILLER_65_302 VDD VDD VSS VSS gf180mcu_fd_sc_mcu7t5v0__fill_1
XFILLER_38_527 VDD VDD VSS VSS gf180mcu_fd_sc_mcu7t5v0__fillcap_16
X_1131_ _2095_/Q _2170_/Q _1133_/A1 VDD VDD VSS VSS gf180mcu_fd_sc_mcu7t5v0__nand2_1
XFILLER_38_549 VDD VDD VSS VSS gf180mcu_fd_sc_mcu7t5v0__fillcap_4
X_1062_ _1062_/A1 _1062_/A2 _1062_/A3 _2154_/D VDD VDD VSS VSS gf180mcu_fd_sc_mcu7t5v0__or3_1
XFILLER_93_688 VDD VDD VSS VSS gf180mcu_fd_sc_mcu7t5v0__fillcap_4
XFILLER_65_368 VDD VDD VSS VSS gf180mcu_fd_sc_mcu7t5v0__fillcap_32
XFILLER_46_593 VDD VDD VSS VSS gf180mcu_fd_sc_mcu7t5v0__fill_2
XFILLER_21_416 VDD VDD VSS VSS gf180mcu_fd_sc_mcu7t5v0__fillcap_4
XFILLER_33_276 VDD VDD VSS VSS gf180mcu_fd_sc_mcu7t5v0__fillcap_4
XFILLER_33_298 VDD VDD VSS VSS gf180mcu_fd_sc_mcu7t5v0__fillcap_8
X_1964_ _1964_/D _2130_/RN _1971_/CLK _1964_/Q VDD VDD VSS VSS gf180mcu_fd_sc_mcu7t5v0__dffrnq_1
X_0915_ _2108_/Q _1753_/C VDD VDD VSS VSS gf180mcu_fd_sc_mcu7t5v0__clkinv_1
X_1895_ _1895_/D _1895_/RN _2152_/CLK _1895_/Q VDD VDD VSS VSS gf180mcu_fd_sc_mcu7t5v0__dffrnq_1
XFILLER_56_313 VDD VDD VSS VSS gf180mcu_fd_sc_mcu7t5v0__fill_2
X_1329_ input38/Z _1319_/C _1332_/A3 _1329_/Z VDD VDD VSS VSS gf180mcu_fd_sc_mcu7t5v0__and3_1
XTAP_TAPCELL_ROW_67_853 VDD VSS gf180mcu_fd_sc_mcu7t5v0__filltie
XFILLER_56_346 VDD VDD VSS VSS gf180mcu_fd_sc_mcu7t5v0__fill_2
XFILLER_33_68 VDD VDD VSS VSS gf180mcu_fd_sc_mcu7t5v0__fill_2
XTAP_TAPCELL_ROW_22_422 VDD VSS gf180mcu_fd_sc_mcu7t5v0__filltie
Xudma_uart_top_505 data_rx_o[29] VDD VDD VSS VSS gf180mcu_fd_sc_mcu7t5v0__tiel
XPHY_EDGE_ROW_89_Left_188 VDD VSS gf180mcu_fd_sc_mcu7t5v0__endcap
XFILLER_75_688 VDD VDD VSS VSS gf180mcu_fd_sc_mcu7t5v0__fillcap_4
XPHY_EDGE_ROW_98_Left_197 VDD VSS gf180mcu_fd_sc_mcu7t5v0__endcap
XFILLER_15_276 VDD VDD VSS VSS gf180mcu_fd_sc_mcu7t5v0__fillcap_4
XFILLER_7_431 VDD VDD VSS VSS gf180mcu_fd_sc_mcu7t5v0__fillcap_8
X_1680_ _2046_/Q _1308_/Z _1684_/S _2046_/D VDD VDD VSS VSS gf180mcu_fd_sc_mcu7t5v0__mux2_2
Xwire362 wire362/I cfg_tx_startaddr_o[1] VDD VDD VSS VSS gf180mcu_fd_sc_mcu7t5v0__clkbuf_3
Xwire373 wire373/I cfg_tx_size_o[2] VDD VDD VSS VSS gf180mcu_fd_sc_mcu7t5v0__clkbuf_3
Xwire384 wire384/I cfg_tx_clr_o VDD VDD VSS VSS gf180mcu_fd_sc_mcu7t5v0__clkbuf_3
Xwire395 wire395/I cfg_rx_startaddr_o[10] VDD VDD VSS VSS gf180mcu_fd_sc_mcu7t5v0__clkbuf_3
XFILLER_7_486 VDD VDD VSS VSS gf180mcu_fd_sc_mcu7t5v0__fillcap_4
XFILLER_3_692 VDD VDD VSS VSS gf180mcu_fd_sc_mcu7t5v0__fill_2
XFILLER_85_419 VDD VDD VSS VSS gf180mcu_fd_sc_mcu7t5v0__fill_1
X_2163_ _2163_/D _2163_/RN _2173_/CLK _2163_/Q VDD VDD VSS VSS gf180mcu_fd_sc_mcu7t5v0__dffrnq_1
X_1114_ _2099_/Q _2174_/Q _1114_/Z VDD VDD VSS VSS gf180mcu_fd_sc_mcu7t5v0__and2_1
XTAP_TAPCELL_ROW_88_1044 VDD VSS gf180mcu_fd_sc_mcu7t5v0__filltie
X_2094_ _2094_/D _2098_/RN _2095_/CLK _2094_/Q VDD VDD VSS VSS gf180mcu_fd_sc_mcu7t5v0__dffrnq_1
XTAP_TAPCELL_ROW_64_823 VDD VSS gf180mcu_fd_sc_mcu7t5v0__filltie
XFILLER_93_496 VDD VDD VSS VSS gf180mcu_fd_sc_mcu7t5v0__fill_2
XFILLER_53_338 VDD VDD VSS VSS gf180mcu_fd_sc_mcu7t5v0__fillcap_4
X_1045_ _2070_/Q _1756_/A1 _1045_/B _1045_/C _2129_/D VDD VDD VSS VSS gf180mcu_fd_sc_mcu7t5v0__aoi211_1
XTAP_TAPCELL_ROW_36_558 VDD VSS gf180mcu_fd_sc_mcu7t5v0__filltie
XFILLER_53_349 VDD VDD VSS VSS gf180mcu_fd_sc_mcu7t5v0__fill_1
X_1947_ _1947_/D _1948_/RN _1949_/CLK _1947_/Q VDD VDD VSS VSS gf180mcu_fd_sc_mcu7t5v0__dffrnq_1
X_1878_ _1878_/D _1886_/RN _1887_/CLK _1878_/Q VDD VDD VSS VSS gf180mcu_fd_sc_mcu7t5v0__dffrnq_1
XFILLER_28_24 VDD VDD VSS VSS gf180mcu_fd_sc_mcu7t5v0__fill_1
XFILLER_69_482 VDD VDD VSS VSS gf180mcu_fd_sc_mcu7t5v0__fill_2
XFILLER_84_474 VDD VDD VSS VSS gf180mcu_fd_sc_mcu7t5v0__fill_2
XFILLER_57_688 VDD VDD VSS VSS gf180mcu_fd_sc_mcu7t5v0__fillcap_4
XFILLER_56_187 VDD VDD VSS VSS gf180mcu_fd_sc_mcu7t5v0__fill_1
XFILLER_25_574 VDD VDD VSS VSS gf180mcu_fd_sc_mcu7t5v0__fill_2
XFILLER_80_691 VDD VDD VSS VSS gf180mcu_fd_sc_mcu7t5v0__fill_2
XFILLER_52_382 VDD VDD VSS VSS gf180mcu_fd_sc_mcu7t5v0__fill_2
XFILLER_60_55 VDD VDD VSS VSS gf180mcu_fd_sc_mcu7t5v0__fill_1
XTAP_TAPCELL_ROW_7_283 VDD VSS gf180mcu_fd_sc_mcu7t5v0__filltie
XFILLER_67_408 VDD VDD VSS VSS gf180mcu_fd_sc_mcu7t5v0__fill_2
XFILLER_90_422 VDD VDD VSS VSS gf180mcu_fd_sc_mcu7t5v0__fillcap_8
XFILLER_16_552 VDD VDD VSS VSS gf180mcu_fd_sc_mcu7t5v0__fillcap_32
XFILLER_62_157 VDD VDD VSS VSS gf180mcu_fd_sc_mcu7t5v0__fill_2
XFILLER_31_500 VDD VDD VSS VSS gf180mcu_fd_sc_mcu7t5v0__fillcap_4
XFILLER_71_680 VDD VDD VSS VSS gf180mcu_fd_sc_mcu7t5v0__fillcap_8
XTAP_TAPCELL_ROW_33_528 VDD VSS gf180mcu_fd_sc_mcu7t5v0__filltie
X_1801_ _1801_/A1 _1801_/A2 _1801_/B _1801_/C _2075_/D VDD VDD VSS VSS gf180mcu_fd_sc_mcu7t5v0__oai211_1
XFILLER_11_290 VDD VDD VSS VSS gf180mcu_fd_sc_mcu7t5v0__fillcap_4
X_1732_ _2066_/Q _1718_/S _1732_/A3 _1732_/B _2066_/D VDD VDD VSS VSS gf180mcu_fd_sc_mcu7t5v0__oai31_1
X_1663_ _2033_/Q input11/Z _1664_/S _2033_/D VDD VDD VSS VSS gf180mcu_fd_sc_mcu7t5v0__mux2_2
X_1594_ _1968_/Q input22/Z _1600_/S _1968_/D VDD VDD VSS VSS gf180mcu_fd_sc_mcu7t5v0__mux2_2
XPHY_EDGE_ROW_7_Right_7 VDD VSS gf180mcu_fd_sc_mcu7t5v0__endcap
XFILLER_85_216 VDD VDD VSS VSS gf180mcu_fd_sc_mcu7t5v0__fill_2
XFILLER_58_419 VDD VDD VSS VSS gf180mcu_fd_sc_mcu7t5v0__fillcap_16
X_2146_ _2146_/D _2151_/RN _2152_/CLK _2146_/Q VDD VDD VSS VSS gf180mcu_fd_sc_mcu7t5v0__dffrnq_1
XFILLER_93_282 VDD VDD VSS VSS gf180mcu_fd_sc_mcu7t5v0__fillcap_16
XFILLER_81_422 VDD VDD VSS VSS gf180mcu_fd_sc_mcu7t5v0__fillcap_8
X_2077_ _2077_/D _2136_/RN _2134_/CLK _2077_/Q VDD VDD VSS VSS gf180mcu_fd_sc_mcu7t5v0__dffsnq_1
X_1028_ _2099_/Q _2144_/Q _1028_/Z VDD VDD VSS VSS gf180mcu_fd_sc_mcu7t5v0__xor2_1
XFILLER_41_308 VDD VDD VSS VSS gf180mcu_fd_sc_mcu7t5v0__fill_1
XFILLER_22_522 VDD VDD VSS VSS gf180mcu_fd_sc_mcu7t5v0__fill_2
XFILLER_62_691 VDD VDD VSS VSS gf180mcu_fd_sc_mcu7t5v0__fill_2
XFILLER_14_37 VDD VDD VSS VSS gf180mcu_fd_sc_mcu7t5v0__fillcap_64
Xclkbuf_4_6_0_sys_clk_i clkbuf_0_sys_clk_i/Z clkbuf_4_6_0_sys_clk_i/Z VDD VDD VSS
+ VSS gf180mcu_fd_sc_mcu7t5v0__clkbuf_2
XFILLER_5_209 VDD VDD VSS VSS gf180mcu_fd_sc_mcu7t5v0__fill_1
XFILLER_30_69 VDD VDD VSS VSS gf180mcu_fd_sc_mcu7t5v0__fillcap_16
XFILLER_1_426 VDD VDD VSS VSS gf180mcu_fd_sc_mcu7t5v0__fill_1
XFILLER_1_459 VDD VDD VSS VSS gf180mcu_fd_sc_mcu7t5v0__fillcap_16
XFILLER_89_555 VDD VDD VSS VSS gf180mcu_fd_sc_mcu7t5v0__fillcap_4
XFILLER_39_34 VDD VDD VSS VSS gf180mcu_fd_sc_mcu7t5v0__fillcap_32
XFILLER_57_430 VDD VDD VSS VSS gf180mcu_fd_sc_mcu7t5v0__fillcap_4
XTAP_TAPCELL_ROW_75_929 VDD VSS gf180mcu_fd_sc_mcu7t5v0__filltie
XTAP_TAPCELL_ROW_4_253 VDD VSS gf180mcu_fd_sc_mcu7t5v0__filltie
XFILLER_17_316 VDD VDD VSS VSS gf180mcu_fd_sc_mcu7t5v0__fillcap_16
XFILLER_72_400 VDD VDD VSS VSS gf180mcu_fd_sc_mcu7t5v0__fillcap_32
XFILLER_17_338 VDD VDD VSS VSS gf180mcu_fd_sc_mcu7t5v0__fill_1
XFILLER_84_293 VDD VDD VSS VSS gf180mcu_fd_sc_mcu7t5v0__fillcap_16
XFILLER_72_444 VDD VDD VSS VSS gf180mcu_fd_sc_mcu7t5v0__fill_2
XFILLER_25_360 VDD VDD VSS VSS gf180mcu_fd_sc_mcu7t5v0__fill_2
XFILLER_72_488 VDD VDD VSS VSS gf180mcu_fd_sc_mcu7t5v0__fillcap_8
XFILLER_72_466 VDD VDD VSS VSS gf180mcu_fd_sc_mcu7t5v0__fillcap_8
XFILLER_13_511 VDD VDD VSS VSS gf180mcu_fd_sc_mcu7t5v0__fill_1
XFILLER_53_691 VDD VDD VSS VSS gf180mcu_fd_sc_mcu7t5v0__fill_2
XFILLER_13_577 VDD VDD VSS VSS gf180mcu_fd_sc_mcu7t5v0__fill_2
XFILLER_9_559 VDD VDD VSS VSS gf180mcu_fd_sc_mcu7t5v0__fill_1
XFILLER_9_537 VDD VDD VSS VSS gf180mcu_fd_sc_mcu7t5v0__fillcap_16
XFILLER_4_286 VDD VDD VSS VSS gf180mcu_fd_sc_mcu7t5v0__fill_1
X_2000_ _2000_/D _2031_/RN _2000_/CLK _2000_/Q VDD VDD VSS VSS gf180mcu_fd_sc_mcu7t5v0__dffrnq_1
XFILLER_48_452 VDD VDD VSS VSS gf180mcu_fd_sc_mcu7t5v0__fill_2
XFILLER_75_282 VDD VDD VSS VSS gf180mcu_fd_sc_mcu7t5v0__fillcap_16
XFILLER_63_422 VDD VDD VSS VSS gf180mcu_fd_sc_mcu7t5v0__fillcap_16
XFILLER_63_411 VDD VDD VSS VSS gf180mcu_fd_sc_mcu7t5v0__fill_1
XFILLER_90_241 VDD VDD VSS VSS gf180mcu_fd_sc_mcu7t5v0__fillcap_4
XFILLER_63_444 VDD VDD VSS VSS gf180mcu_fd_sc_mcu7t5v0__fill_1
XTAP_TAPCELL_ROW_46_653 VDD VSS gf180mcu_fd_sc_mcu7t5v0__filltie
XTAP_TAPCELL_ROW_18_388 VDD VSS gf180mcu_fd_sc_mcu7t5v0__filltie
XFILLER_84_2 VDD VDD VSS VSS gf180mcu_fd_sc_mcu7t5v0__fillcap_32
X_1715_ _2159_/Q _2101_/Q _1724_/A3 VDD VDD VSS VSS gf180mcu_fd_sc_mcu7t5v0__nand2_1
XTAP_TAPCELL_ROW_96_1121 VDD VSS gf180mcu_fd_sc_mcu7t5v0__filltie
X_1646_ _2017_/Q input7/Z _1647_/S _2017_/D VDD VDD VSS VSS gf180mcu_fd_sc_mcu7t5v0__mux2_2
X_1577_ _1577_/A1 _1550_/B _1577_/Z VDD VDD VSS VSS gf180mcu_fd_sc_mcu7t5v0__xor2_1
XFILLER_73_208 VDD VDD VSS VSS gf180mcu_fd_sc_mcu7t5v0__fill_2
XTAP_TAPCELL_ROW_1_223 VDD VSS gf180mcu_fd_sc_mcu7t5v0__filltie
X_2129_ _2129_/D _2139_/RN _2129_/CLK _2129_/Q VDD VDD VSS VSS gf180mcu_fd_sc_mcu7t5v0__dffrnq_1
XFILLER_94_591 VDD VDD VSS VSS gf180mcu_fd_sc_mcu7t5v0__fillcap_4
XFILLER_25_36 VDD VDD VSS VSS gf180mcu_fd_sc_mcu7t5v0__fill_1
XFILLER_81_274 VDD VDD VSS VSS gf180mcu_fd_sc_mcu7t5v0__fillcap_4
XFILLER_22_341 VDD VDD VSS VSS gf180mcu_fd_sc_mcu7t5v0__fillcap_8
XTAP_TAPCELL_ROW_80_976 VDD VSS gf180mcu_fd_sc_mcu7t5v0__filltie
XFILLER_6_507 VDD VDD VSS VSS gf180mcu_fd_sc_mcu7t5v0__fillcap_16
XTAP_TAPCELL_ROW_9_301 VDD VSS gf180mcu_fd_sc_mcu7t5v0__filltie
XFILLER_1_212 VDD VDD VSS VSS gf180mcu_fd_sc_mcu7t5v0__fillcap_4
XFILLER_85_580 VDD VDD VSS VSS gf180mcu_fd_sc_mcu7t5v0__fillcap_8
XFILLER_17_124 VDD VDD VSS VSS gf180mcu_fd_sc_mcu7t5v0__fill_1
XFILLER_18_647 VDD VDD VSS VSS gf180mcu_fd_sc_mcu7t5v0__fillcap_16
XFILLER_57_282 VDD VDD VSS VSS gf180mcu_fd_sc_mcu7t5v0__fillcap_8
XTAP_TAPCELL_ROW_43_623 VDD VSS gf180mcu_fd_sc_mcu7t5v0__filltie
XFILLER_13_352 VDD VDD VSS VSS gf180mcu_fd_sc_mcu7t5v0__fillcap_32
XTAP_TAPCELL_ROW_15_358 VDD VSS gf180mcu_fd_sc_mcu7t5v0__filltie
XFILLER_13_396 VDD VDD VSS VSS gf180mcu_fd_sc_mcu7t5v0__fill_2
XFILLER_40_193 VDD VDD VSS VSS gf180mcu_fd_sc_mcu7t5v0__fill_2
X_1500_ _1510_/A2 _1527_/A2 _1500_/B _1911_/D VDD VDD VSS VSS gf180mcu_fd_sc_mcu7t5v0__oai21_1
Xoutput119 _1405_/ZN wire243/I VDD VDD VSS VSS gf180mcu_fd_sc_mcu7t5v0__buf_1
X_1431_ _1878_/Q _2062_/Q _1431_/S _1878_/D VDD VDD VSS VSS gf180mcu_fd_sc_mcu7t5v0__mux2_2
XTAP_TAPCELL_ROW_91_1073 VDD VSS gf180mcu_fd_sc_mcu7t5v0__filltie
X_1362_ input78/Z _1395_/A2 _1396_/A2 input48/Z _1363_/A2 VDD VDD VSS VSS gf180mcu_fd_sc_mcu7t5v0__aoi22_1
X_1293_ _2168_/Q _2173_/Q _1297_/A2 _1288_/Z _1295_/A2 VDD VDD VSS VSS gf180mcu_fd_sc_mcu7t5v0__nand4_1
XFILLER_83_539 VDD VDD VSS VSS gf180mcu_fd_sc_mcu7t5v0__fillcap_16
XFILLER_55_208 VDD VDD VSS VSS gf180mcu_fd_sc_mcu7t5v0__fill_2
XFILLER_48_271 VDD VDD VSS VSS gf180mcu_fd_sc_mcu7t5v0__fill_1
X_1629_ _2001_/Q input8/Z _1633_/S _2001_/D VDD VDD VSS VSS gf180mcu_fd_sc_mcu7t5v0__mux2_2
Xfanout313 _1835_/ZN _1855_/S VDD VDD VSS VSS gf180mcu_fd_sc_mcu7t5v0__dlyb_1
Xfanout324 _1333_/Z _1404_/B1 VDD VDD VSS VSS gf180mcu_fd_sc_mcu7t5v0__dlyb_1
Xfanout335 _1496_/A3 _1511_/C VDD VDD VSS VSS gf180mcu_fd_sc_mcu7t5v0__dlyb_1
Xfanout346 _1895_/RN fanout346/Z VDD VDD VSS VSS gf180mcu_fd_sc_mcu7t5v0__buf_1
XFILLER_67_591 VDD VDD VSS VSS gf180mcu_fd_sc_mcu7t5v0__fillcap_4
XFILLER_14_127 VDD VDD VSS VSS gf180mcu_fd_sc_mcu7t5v0__fillcap_8
XFILLER_27_488 VDD VDD VSS VSS gf180mcu_fd_sc_mcu7t5v0__fill_2
XFILLER_42_469 VDD VDD VSS VSS gf180mcu_fd_sc_mcu7t5v0__fill_1
XFILLER_52_45 VDD VDD VSS VSS gf180mcu_fd_sc_mcu7t5v0__fill_1
XFILLER_52_34 VDD VDD VSS VSS gf180mcu_fd_sc_mcu7t5v0__fill_1
XFILLER_22_171 VDD VDD VSS VSS gf180mcu_fd_sc_mcu7t5v0__fillcap_4
XFILLER_22_193 VDD VDD VSS VSS gf180mcu_fd_sc_mcu7t5v0__fillcap_8
XTAP_TAPCELL_ROW_12_328 VDD VSS gf180mcu_fd_sc_mcu7t5v0__filltie
XFILLER_6_326 VDD VDD VSS VSS gf180mcu_fd_sc_mcu7t5v0__fillcap_4
XPHY_EDGE_ROW_70_Left_169 VDD VSS gf180mcu_fd_sc_mcu7t5v0__endcap
XFILLER_2_521 VDD VDD VSS VSS gf180mcu_fd_sc_mcu7t5v0__fillcap_4
XFILLER_2_565 VDD VDD VSS VSS gf180mcu_fd_sc_mcu7t5v0__fill_1
XFILLER_73_550 VDD VDD VSS VSS gf180mcu_fd_sc_mcu7t5v0__fillcap_8
XFILLER_45_241 VDD VDD VSS VSS gf180mcu_fd_sc_mcu7t5v0__fillcap_8
XTAP_TAPCELL_ROW_28_483 VDD VSS gf180mcu_fd_sc_mcu7t5v0__filltie
XFILLER_73_594 VDD VDD VSS VSS gf180mcu_fd_sc_mcu7t5v0__fillcap_8
X_1980_ _1980_/D _2032_/RN _2025_/CLK _1980_/Q VDD VDD VSS VSS gf180mcu_fd_sc_mcu7t5v0__dffrnq_1
XFILLER_14_661 VDD VDD VSS VSS gf180mcu_fd_sc_mcu7t5v0__fillcap_4
XFILLER_14_683 VDD VDD VSS VSS gf180mcu_fd_sc_mcu7t5v0__fillcap_4
XFILLER_20_119 VDD VDD VSS VSS gf180mcu_fd_sc_mcu7t5v0__fill_2
X_0931_ _1691_/C _1703_/B VDD VDD VSS VSS gf180mcu_fd_sc_mcu7t5v0__clkinv_1
XFILLER_60_299 VDD VDD VSS VSS gf180mcu_fd_sc_mcu7t5v0__fill_1
XFILLER_47_2 VDD VDD VSS VSS gf180mcu_fd_sc_mcu7t5v0__fillcap_8
X_1414_ _1863_/Q _2063_/Q _1414_/S _1863_/D VDD VDD VSS VSS gf180mcu_fd_sc_mcu7t5v0__mux2_2
X_1345_ _2042_/Q _1673_/A2 _1345_/A3 _1346_/A3 VDD VDD VSS VSS gf180mcu_fd_sc_mcu7t5v0__nand3_1
XFILLER_3_72 VDD VDD VSS VSS gf180mcu_fd_sc_mcu7t5v0__fillcap_4
XFILLER_3_50 VDD VDD VSS VSS gf180mcu_fd_sc_mcu7t5v0__fillcap_4
X_1276_ _1294_/A1 _1276_/A2 _1281_/A2 _1294_/A4 _2168_/D VDD VDD VSS VSS gf180mcu_fd_sc_mcu7t5v0__and4_1
XTAP_TAPCELL_ROW_54_729 VDD VSS gf180mcu_fd_sc_mcu7t5v0__filltie
XFILLER_91_380 VDD VDD VSS VSS gf180mcu_fd_sc_mcu7t5v0__fillcap_8
XFILLER_51_244 VDD VDD VSS VSS gf180mcu_fd_sc_mcu7t5v0__fillcap_16
XFILLER_51_277 VDD VDD VSS VSS gf180mcu_fd_sc_mcu7t5v0__fill_2
XFILLER_32_491 VDD VDD VSS VSS gf180mcu_fd_sc_mcu7t5v0__fillcap_16
XFILLER_22_37 VDD VDD VSS VSS gf180mcu_fd_sc_mcu7t5v0__fillcap_64
XFILLER_59_322 VDD VDD VSS VSS gf180mcu_fd_sc_mcu7t5v0__fillcap_8
XFILLER_87_664 VDD VDD VSS VSS gf180mcu_fd_sc_mcu7t5v0__fillcap_16
XFILLER_19_208 VDD VDD VSS VSS gf180mcu_fd_sc_mcu7t5v0__fill_2
XFILLER_74_347 VDD VDD VSS VSS gf180mcu_fd_sc_mcu7t5v0__fillcap_4
XFILLER_74_325 VDD VDD VSS VSS gf180mcu_fd_sc_mcu7t5v0__fillcap_4
XFILLER_63_66 VDD VDD VSS VSS gf180mcu_fd_sc_mcu7t5v0__fillcap_4
XTAP_TAPCELL_ROW_25_453 VDD VSS gf180mcu_fd_sc_mcu7t5v0__filltie
XFILLER_70_597 VDD VDD VSS VSS gf180mcu_fd_sc_mcu7t5v0__fillcap_8
XFILLER_11_664 VDD VDD VSS VSS gf180mcu_fd_sc_mcu7t5v0__fillcap_16
XFILLER_2_384 VDD VDD VSS VSS gf180mcu_fd_sc_mcu7t5v0__fill_1
XFILLER_78_653 VDD VDD VSS VSS gf180mcu_fd_sc_mcu7t5v0__fillcap_8
X_1130_ _1115_/Z _1130_/A2 _1130_/A3 _1143_/A1 VDD VDD VSS VSS gf180mcu_fd_sc_mcu7t5v0__nor3_1
XFILLER_77_185 VDD VDD VSS VSS gf180mcu_fd_sc_mcu7t5v0__fillcap_4
X_1061_ _1311_/S1 _1061_/A2 _1061_/B _1062_/A3 VDD VDD VSS VSS gf180mcu_fd_sc_mcu7t5v0__aoi21_1
XFILLER_80_306 VDD VDD VSS VSS gf180mcu_fd_sc_mcu7t5v0__fill_1
XFILLER_92_177 VDD VDD VSS VSS gf180mcu_fd_sc_mcu7t5v0__fillcap_64
XFILLER_80_317 VDD VDD VSS VSS gf180mcu_fd_sc_mcu7t5v0__fill_2
X_1963_ _1963_/D _1963_/RN _1975_/CLK _1963_/Q VDD VDD VSS VSS gf180mcu_fd_sc_mcu7t5v0__dffrnq_1
X_1894_ _1894_/D _1895_/RN clkload2/I _1894_/Q VDD VDD VSS VSS gf180mcu_fd_sc_mcu7t5v0__dffrnq_1
X_0914_ _2070_/Q _1754_/B1 VDD VDD VSS VSS gf180mcu_fd_sc_mcu7t5v0__clkinv_1
XFILLER_69_664 VDD VDD VSS VSS gf180mcu_fd_sc_mcu7t5v0__fillcap_16
X_1328_ input1/Z _1173_/Z _1328_/B _1353_/A2 VDD VDD VSS VSS gf180mcu_fd_sc_mcu7t5v0__aoi21_1
XFILLER_83_122 VDD VDD VSS VSS gf180mcu_fd_sc_mcu7t5v0__fillcap_16
XFILLER_68_174 VDD VDD VSS VSS gf180mcu_fd_sc_mcu7t5v0__fill_1
XFILLER_56_325 VDD VDD VSS VSS gf180mcu_fd_sc_mcu7t5v0__fillcap_4
X_1259_ _1259_/A1 _1259_/A2 _1262_/A2 VDD VDD VSS VSS gf180mcu_fd_sc_mcu7t5v0__nand2_1
XFILLER_84_667 VDD VDD VSS VSS gf180mcu_fd_sc_mcu7t5v0__fillcap_16
XFILLER_52_520 VDD VDD VSS VSS gf180mcu_fd_sc_mcu7t5v0__fillcap_4
XFILLER_52_542 VDD VDD VSS VSS gf180mcu_fd_sc_mcu7t5v0__fillcap_4
XTAP_TAPCELL_ROW_22_423 VDD VSS gf180mcu_fd_sc_mcu7t5v0__filltie
Xudma_uart_top_506 data_rx_o[30] VDD VDD VSS VSS gf180mcu_fd_sc_mcu7t5v0__tiel
XFILLER_47_336 VDD VDD VSS VSS gf180mcu_fd_sc_mcu7t5v0__fillcap_8
XFILLER_28_594 VDD VDD VSS VSS gf180mcu_fd_sc_mcu7t5v0__fill_1
XFILLER_74_177 VDD VDD VSS VSS gf180mcu_fd_sc_mcu7t5v0__fillcap_8
XFILLER_62_317 VDD VDD VSS VSS gf180mcu_fd_sc_mcu7t5v0__fillcap_8
XFILLER_30_225 VDD VDD VSS VSS gf180mcu_fd_sc_mcu7t5v0__fillcap_16
XFILLER_30_247 VDD VDD VSS VSS gf180mcu_fd_sc_mcu7t5v0__fillcap_8
Xwire363 wire363/I cfg_tx_startaddr_o[11] VDD VDD VSS VSS gf180mcu_fd_sc_mcu7t5v0__clkbuf_3
Xwire374 wire374/I cfg_tx_size_o[1] VDD VDD VSS VSS gf180mcu_fd_sc_mcu7t5v0__clkbuf_3
XFILLER_7_443 VDD VDD VSS VSS gf180mcu_fd_sc_mcu7t5v0__fill_1
Xwire385 wire385/I cfg_rx_startaddr_o[9] VDD VDD VSS VSS gf180mcu_fd_sc_mcu7t5v0__clkbuf_3
Xwire396 wire396/I cfg_rx_startaddr_o[0] VDD VDD VSS VSS gf180mcu_fd_sc_mcu7t5v0__clkbuf_3
XFILLER_2_181 VDD VDD VSS VSS gf180mcu_fd_sc_mcu7t5v0__fill_1
XFILLER_78_472 VDD VDD VSS VSS gf180mcu_fd_sc_mcu7t5v0__fill_1
X_2162_ _2162_/D _2163_/RN _2173_/CLK _2162_/Q VDD VDD VSS VSS gf180mcu_fd_sc_mcu7t5v0__dffrnq_1
X_2093_ _2093_/D _2097_/RN _2095_/CLK _2093_/Q VDD VDD VSS VSS gf180mcu_fd_sc_mcu7t5v0__dffrnq_1
X_1113_ _2099_/Q _2174_/Q _1157_/A1 VDD VDD VSS VSS gf180mcu_fd_sc_mcu7t5v0__nor2_1
XTAP_TAPCELL_ROW_88_1045 VDD VSS gf180mcu_fd_sc_mcu7t5v0__filltie
XFILLER_66_667 VDD VDD VSS VSS gf180mcu_fd_sc_mcu7t5v0__fillcap_16
X_1044_ _2070_/Q _1756_/A1 _1045_/C _1196_/A2 VDD VDD VSS VSS gf180mcu_fd_sc_mcu7t5v0__aoi21_1
XTAP_TAPCELL_ROW_64_824 VDD VSS gf180mcu_fd_sc_mcu7t5v0__filltie
XFILLER_81_648 VDD VDD VSS VSS gf180mcu_fd_sc_mcu7t5v0__fillcap_8
XTAP_TAPCELL_ROW_36_559 VDD VSS gf180mcu_fd_sc_mcu7t5v0__filltie
XFILLER_80_136 VDD VDD VSS VSS gf180mcu_fd_sc_mcu7t5v0__fill_1
XFILLER_34_575 VDD VDD VSS VSS gf180mcu_fd_sc_mcu7t5v0__fillcap_4
XFILLER_34_597 VDD VDD VSS VSS gf180mcu_fd_sc_mcu7t5v0__fillcap_8
Xclkbuf_4_5_0_sys_clk_i clkbuf_0_sys_clk_i/Z clkbuf_4_5_0_sys_clk_i/Z VDD VDD VSS
+ VSS gf180mcu_fd_sc_mcu7t5v0__clkbuf_2
X_1946_ _1946_/D _1954_/RN _1954_/CLK _1946_/Q VDD VDD VSS VSS gf180mcu_fd_sc_mcu7t5v0__dffrnq_1
X_1877_ _1877_/D _2156_/RN _2182_/CLK _1877_/Q VDD VDD VSS VSS gf180mcu_fd_sc_mcu7t5v0__dffrnq_1
XFILLER_88_247 VDD VDD VSS VSS gf180mcu_fd_sc_mcu7t5v0__fillcap_16
XFILLER_29_314 VDD VDD VSS VSS gf180mcu_fd_sc_mcu7t5v0__fillcap_4
XFILLER_56_111 VDD VDD VSS VSS gf180mcu_fd_sc_mcu7t5v0__fill_1
XFILLER_56_177 VDD VDD VSS VSS gf180mcu_fd_sc_mcu7t5v0__fillcap_8
XFILLER_44_317 VDD VDD VSS VSS gf180mcu_fd_sc_mcu7t5v0__fillcap_4
XFILLER_72_659 VDD VDD VSS VSS gf180mcu_fd_sc_mcu7t5v0__fillcap_4
XFILLER_12_247 VDD VDD VSS VSS gf180mcu_fd_sc_mcu7t5v0__fill_2
Xclkbuf_5_2__f_periph_clk_i clkbuf_4_1_0_periph_clk_i/Z _2187_/CLK VDD VDD VSS VSS
+ gf180mcu_fd_sc_mcu7t5v0__clkbuf_16
XFILLER_4_457 VDD VDD VSS VSS gf180mcu_fd_sc_mcu7t5v0__fillcap_16
XFILLER_4_446 VDD VDD VSS VSS gf180mcu_fd_sc_mcu7t5v0__fillcap_8
XTAP_TAPCELL_ROW_78_949 VDD VSS gf180mcu_fd_sc_mcu7t5v0__filltie
XFILLER_48_667 VDD VDD VSS VSS gf180mcu_fd_sc_mcu7t5v0__fill_2
XFILLER_35_306 VDD VDD VSS VSS gf180mcu_fd_sc_mcu7t5v0__fillcap_4
XFILLER_16_520 VDD VDD VSS VSS gf180mcu_fd_sc_mcu7t5v0__fillcap_4
XFILLER_16_531 VDD VDD VSS VSS gf180mcu_fd_sc_mcu7t5v0__fill_2
XFILLER_90_467 VDD VDD VSS VSS gf180mcu_fd_sc_mcu7t5v0__fill_1
XTAP_TAPCELL_ROW_33_529 VDD VSS gf180mcu_fd_sc_mcu7t5v0__filltie
XFILLER_71_692 VDD VDD VSS VSS gf180mcu_fd_sc_mcu7t5v0__fill_2
XFILLER_31_556 VDD VDD VSS VSS gf180mcu_fd_sc_mcu7t5v0__fillcap_4
X_1800_ _1822_/B _1800_/A2 _1801_/A2 VDD VDD VSS VSS gf180mcu_fd_sc_mcu7t5v0__nand2_1
X_1731_ _1728_/Z _1718_/S _2066_/Q _1732_/B VDD VDD VSS VSS gf180mcu_fd_sc_mcu7t5v0__oai21_1
X_1662_ _2032_/Q input10/Z _1662_/S _2032_/D VDD VDD VSS VSS gf180mcu_fd_sc_mcu7t5v0__mux2_2
X_1593_ _1967_/Q input21/Z _1596_/S _1967_/D VDD VDD VSS VSS gf180mcu_fd_sc_mcu7t5v0__mux2_2
XFILLER_85_206 VDD VDD VSS VSS gf180mcu_fd_sc_mcu7t5v0__fillcap_4
X_2145_ _2145_/D _2160_/RN _2172_/CLK _2145_/Q VDD VDD VSS VSS gf180mcu_fd_sc_mcu7t5v0__dffrnq_1
XFILLER_53_114 VDD VDD VSS VSS gf180mcu_fd_sc_mcu7t5v0__fillcap_8
XFILLER_38_177 VDD VDD VSS VSS gf180mcu_fd_sc_mcu7t5v0__fillcap_16
X_2076_ _2076_/D _2139_/RN _2134_/CLK _2076_/Q VDD VDD VSS VSS gf180mcu_fd_sc_mcu7t5v0__dffsnq_1
XFILLER_81_434 VDD VDD VSS VSS gf180mcu_fd_sc_mcu7t5v0__fill_1
XFILLER_53_136 VDD VDD VSS VSS gf180mcu_fd_sc_mcu7t5v0__fillcap_4
X_1027_ _2097_/Q _2142_/Q _1038_/A3 VDD VDD VSS VSS gf180mcu_fd_sc_mcu7t5v0__xnor2_1
XFILLER_81_489 VDD VDD VSS VSS gf180mcu_fd_sc_mcu7t5v0__fill_1
XFILLER_14_27 VDD VDD VSS VSS gf180mcu_fd_sc_mcu7t5v0__fillcap_8
XFILLER_34_383 VDD VDD VSS VSS gf180mcu_fd_sc_mcu7t5v0__fill_2
X_1929_ _1929_/D _1948_/RN _1952_/CLK _2123_/D VDD VDD VSS VSS gf180mcu_fd_sc_mcu7t5v0__dffrnq_1
XFILLER_30_26 VDD VDD VSS VSS gf180mcu_fd_sc_mcu7t5v0__fill_1
XFILLER_30_37 VDD VDD VSS VSS gf180mcu_fd_sc_mcu7t5v0__fillcap_32
XTAP_TAPCELL_ROW_4_254 VDD VSS gf180mcu_fd_sc_mcu7t5v0__filltie
Xclkbuf_5_17__f_periph_clk_i clkbuf_4_8_0_periph_clk_i/Z _2129_/CLK VDD VDD VSS VSS
+ gf180mcu_fd_sc_mcu7t5v0__clkbuf_16
XFILLER_44_103 VDD VDD VSS VSS gf180mcu_fd_sc_mcu7t5v0__fill_2
XFILLER_44_136 VDD VDD VSS VSS gf180mcu_fd_sc_mcu7t5v0__fillcap_8
XFILLER_55_89 VDD VDD VSS VSS gf180mcu_fd_sc_mcu7t5v0__fill_1
XFILLER_13_556 VDD VDD VSS VSS gf180mcu_fd_sc_mcu7t5v0__fillcap_4
XFILLER_96_30 VDD VDD VSS VSS gf180mcu_fd_sc_mcu7t5v0__fillcap_4
XFILLER_95_537 VDD VDD VSS VSS gf180mcu_fd_sc_mcu7t5v0__fillcap_16
XFILLER_67_228 VDD VDD VSS VSS gf180mcu_fd_sc_mcu7t5v0__fillcap_4
XFILLER_95_559 VDD VDD VSS VSS gf180mcu_fd_sc_mcu7t5v0__fill_1
XFILLER_82_209 VDD VDD VSS VSS gf180mcu_fd_sc_mcu7t5v0__fillcap_16
XFILLER_35_136 VDD VDD VSS VSS gf180mcu_fd_sc_mcu7t5v0__fillcap_4
XFILLER_35_158 VDD VDD VSS VSS gf180mcu_fd_sc_mcu7t5v0__fill_2
XTAP_TAPCELL_ROW_46_654 VDD VSS gf180mcu_fd_sc_mcu7t5v0__filltie
XFILLER_63_489 VDD VDD VSS VSS gf180mcu_fd_sc_mcu7t5v0__fill_1
XFILLER_77_2 VDD VDD VSS VSS gf180mcu_fd_sc_mcu7t5v0__fillcap_16
X_1714_ _1714_/I0 _2060_/Q _1718_/S _2060_/D VDD VDD VSS VSS gf180mcu_fd_sc_mcu7t5v0__mux2_2
XTAP_TAPCELL_ROW_96_1122 VDD VSS gf180mcu_fd_sc_mcu7t5v0__filltie
XFILLER_8_593 VDD VDD VSS VSS gf180mcu_fd_sc_mcu7t5v0__fill_2
X_1645_ _2016_/Q input37/Z _1645_/S _2016_/D VDD VDD VSS VSS gf180mcu_fd_sc_mcu7t5v0__mux2_2
X_1576_ _1576_/I0 _1955_/Q _1576_/S _1955_/D VDD VDD VSS VSS gf180mcu_fd_sc_mcu7t5v0__mux2_2
XFILLER_98_342 VDD VDD VSS VSS gf180mcu_fd_sc_mcu7t5v0__fill_2
XFILLER_86_515 VDD VDD VSS VSS gf180mcu_fd_sc_mcu7t5v0__fillcap_8
XTAP_TAPCELL_ROW_1_224 VDD VSS gf180mcu_fd_sc_mcu7t5v0__filltie
X_2128_ _2128_/D _2128_/RN _2128_/CLK _2128_/Q VDD VDD VSS VSS gf180mcu_fd_sc_mcu7t5v0__dffrnq_1
XFILLER_14_309 VDD VDD VSS VSS gf180mcu_fd_sc_mcu7t5v0__fillcap_4
X_2059_ _2059_/D _2161_/RN _2171_/CLK _2059_/Q VDD VDD VSS VSS gf180mcu_fd_sc_mcu7t5v0__dffsnq_1
XFILLER_54_489 VDD VDD VSS VSS gf180mcu_fd_sc_mcu7t5v0__fillcap_8
XTAP_TAPCELL_ROW_80_977 VDD VSS gf180mcu_fd_sc_mcu7t5v0__filltie
XFILLER_41_36 VDD VDD VSS VSS gf180mcu_fd_sc_mcu7t5v0__fill_1
XTAP_TAPCELL_ROW_9_302 VDD VSS gf180mcu_fd_sc_mcu7t5v0__filltie
XFILLER_89_386 VDD VDD VSS VSS gf180mcu_fd_sc_mcu7t5v0__fillcap_4
XFILLER_77_559 VDD VDD VSS VSS gf180mcu_fd_sc_mcu7t5v0__fill_1
XFILLER_92_518 VDD VDD VSS VSS gf180mcu_fd_sc_mcu7t5v0__fillcap_4
XFILLER_66_99 VDD VDD VSS VSS gf180mcu_fd_sc_mcu7t5v0__fillcap_4
XTAP_TAPCELL_ROW_43_624 VDD VSS gf180mcu_fd_sc_mcu7t5v0__filltie
XFILLER_45_489 VDD VDD VSS VSS gf180mcu_fd_sc_mcu7t5v0__fill_1
XTAP_TAPCELL_ROW_15_359 VDD VSS gf180mcu_fd_sc_mcu7t5v0__filltie
XFILLER_9_313 VDD VDD VSS VSS gf180mcu_fd_sc_mcu7t5v0__fillcap_16
XFILLER_9_346 VDD VDD VSS VSS gf180mcu_fd_sc_mcu7t5v0__fillcap_4
X_1430_ _1877_/Q _2061_/Q _1430_/S _1877_/D VDD VDD VSS VSS gf180mcu_fd_sc_mcu7t5v0__mux2_2
XFILLER_5_596 VDD VDD VSS VSS gf180mcu_fd_sc_mcu7t5v0__fillcap_32
X_1361_ _1958_/Q _1179_/Z _1325_/Z _2046_/Q _1363_/A1 VDD VDD VSS VSS gf180mcu_fd_sc_mcu7t5v0__aoi22_1
XTAP_TAPCELL_ROW_91_1074 VDD VSS gf180mcu_fd_sc_mcu7t5v0__filltie
X_1292_ _1296_/A1 _1292_/A2 _1294_/A2 VDD VDD VSS VSS gf180mcu_fd_sc_mcu7t5v0__nand2_1
XFILLER_83_518 VDD VDD VSS VSS gf180mcu_fd_sc_mcu7t5v0__fillcap_4
XFILLER_76_570 VDD VDD VSS VSS gf180mcu_fd_sc_mcu7t5v0__fillcap_4
XFILLER_91_562 VDD VDD VSS VSS gf180mcu_fd_sc_mcu7t5v0__fillcap_64
X_1628_ _2000_/Q input7/Z _1633_/S _2000_/D VDD VDD VSS VSS gf180mcu_fd_sc_mcu7t5v0__mux2_2
Xfanout314 _1708_/S _1718_/S VDD VDD VSS VSS gf180mcu_fd_sc_mcu7t5v0__dlyb_1
X_1559_ _1938_/Q _1559_/A2 _1938_/D VDD VDD VSS VSS gf180mcu_fd_sc_mcu7t5v0__xor2_1
Xfanout325 _1332_/ZN _1395_/A2 VDD VDD VSS VSS gf180mcu_fd_sc_mcu7t5v0__dlya_1
Xfanout336 _1333_/A1 _1191_/A3 VDD VDD VSS VSS gf180mcu_fd_sc_mcu7t5v0__dlyb_1
Xfanout347 _2155_/RN _1895_/RN VDD VDD VSS VSS gf180mcu_fd_sc_mcu7t5v0__dlyb_1
XFILLER_98_172 VDD VDD VSS VSS gf180mcu_fd_sc_mcu7t5v0__fillcap_32
XFILLER_67_570 VDD VDD VSS VSS gf180mcu_fd_sc_mcu7t5v0__fillcap_4
XFILLER_27_456 VDD VDD VSS VSS gf180mcu_fd_sc_mcu7t5v0__fillcap_32
XFILLER_15_629 VDD VDD VSS VSS gf180mcu_fd_sc_mcu7t5v0__fill_1
XFILLER_14_139 VDD VDD VSS VSS gf180mcu_fd_sc_mcu7t5v0__fill_2
XFILLER_23_662 VDD VDD VSS VSS gf180mcu_fd_sc_mcu7t5v0__fillcap_4
XFILLER_50_470 VDD VDD VSS VSS gf180mcu_fd_sc_mcu7t5v0__fillcap_16
XTAP_TAPCELL_ROW_12_329 VDD VSS gf180mcu_fd_sc_mcu7t5v0__filltie
XFILLER_10_367 VDD VDD VSS VSS gf180mcu_fd_sc_mcu7t5v0__fillcap_16
XFILLER_10_389 VDD VDD VSS VSS gf180mcu_fd_sc_mcu7t5v0__fill_1
XFILLER_7_2 VDD VDD VSS VSS gf180mcu_fd_sc_mcu7t5v0__fillcap_64
XFILLER_77_54 VDD VDD VSS VSS gf180mcu_fd_sc_mcu7t5v0__fill_1
XFILLER_77_301 VDD VDD VSS VSS gf180mcu_fd_sc_mcu7t5v0__fillcap_4
XFILLER_77_356 VDD VDD VSS VSS gf180mcu_fd_sc_mcu7t5v0__fill_2
XFILLER_77_334 VDD VDD VSS VSS gf180mcu_fd_sc_mcu7t5v0__fill_1
XFILLER_37_209 VDD VDD VSS VSS gf180mcu_fd_sc_mcu7t5v0__fill_1
XFILLER_45_220 VDD VDD VSS VSS gf180mcu_fd_sc_mcu7t5v0__fill_2
XFILLER_73_562 VDD VDD VSS VSS gf180mcu_fd_sc_mcu7t5v0__fillcap_8
XFILLER_18_489 VDD VDD VSS VSS gf180mcu_fd_sc_mcu7t5v0__fillcap_4
XFILLER_33_426 VDD VDD VSS VSS gf180mcu_fd_sc_mcu7t5v0__fill_2
XFILLER_26_80 VDD VDD VSS VSS gf180mcu_fd_sc_mcu7t5v0__fillcap_16
X_0930_ _1703_/C _1161_/A1 VDD VDD VSS VSS gf180mcu_fd_sc_mcu7t5v0__clkinv_1
XFILLER_41_492 VDD VDD VSS VSS gf180mcu_fd_sc_mcu7t5v0__fillcap_8
X_1413_ _1862_/Q _2062_/Q _1414_/S _1862_/D VDD VDD VSS VSS gf180mcu_fd_sc_mcu7t5v0__mux2_2
XFILLER_68_301 VDD VDD VSS VSS gf180mcu_fd_sc_mcu7t5v0__fill_2
X_1344_ _1376_/A1 _1329_/Z _2006_/Q _1376_/A2 _1346_/A2 VDD VDD VSS VSS gf180mcu_fd_sc_mcu7t5v0__nand4_1
X_1275_ _2168_/Q _1278_/A3 _1281_/A2 VDD VDD VSS VSS gf180mcu_fd_sc_mcu7t5v0__nand2_1
XFILLER_95_142 VDD VDD VSS VSS gf180mcu_fd_sc_mcu7t5v0__fillcap_64
XFILLER_51_212 VDD VDD VSS VSS gf180mcu_fd_sc_mcu7t5v0__fillcap_32
XFILLER_20_676 VDD VDD VSS VSS gf180mcu_fd_sc_mcu7t5v0__fill_2
XFILLER_87_621 VDD VDD VSS VSS gf180mcu_fd_sc_mcu7t5v0__fillcap_8
XFILLER_87_632 VDD VDD VSS VSS gf180mcu_fd_sc_mcu7t5v0__fillcap_32
XPHY_EDGE_ROW_29_Right_29 VDD VSS gf180mcu_fd_sc_mcu7t5v0__endcap
XFILLER_47_68 VDD VDD VSS VSS gf180mcu_fd_sc_mcu7t5v0__fill_2
XFILLER_55_562 VDD VDD VSS VSS gf180mcu_fd_sc_mcu7t5v0__fillcap_16
XFILLER_70_543 VDD VDD VSS VSS gf180mcu_fd_sc_mcu7t5v0__fillcap_4
XTAP_TAPCELL_ROW_25_454 VDD VSS gf180mcu_fd_sc_mcu7t5v0__filltie
XFILLER_11_632 VDD VDD VSS VSS gf180mcu_fd_sc_mcu7t5v0__fillcap_32
XFILLER_23_470 VDD VDD VSS VSS gf180mcu_fd_sc_mcu7t5v0__fillcap_8
XPHY_EDGE_ROW_38_Right_38 VDD VSS gf180mcu_fd_sc_mcu7t5v0__endcap
XFILLER_7_625 VDD VDD VSS VSS gf180mcu_fd_sc_mcu7t5v0__fillcap_4
XPHY_EDGE_ROW_47_Right_47 VDD VSS gf180mcu_fd_sc_mcu7t5v0__endcap
XFILLER_77_142 VDD VDD VSS VSS gf180mcu_fd_sc_mcu7t5v0__fillcap_4
XFILLER_38_507 VDD VDD VSS VSS gf180mcu_fd_sc_mcu7t5v0__fillcap_16
XFILLER_92_101 VDD VDD VSS VSS gf180mcu_fd_sc_mcu7t5v0__fillcap_4
XFILLER_65_337 VDD VDD VSS VSS gf180mcu_fd_sc_mcu7t5v0__fillcap_8
XFILLER_18_242 VDD VDD VSS VSS gf180mcu_fd_sc_mcu7t5v0__fill_2
X_1060_ _2153_/D _2150_/D _1061_/B VDD VDD VSS VSS gf180mcu_fd_sc_mcu7t5v0__nand2_1
XFILLER_33_212 VDD VDD VSS VSS gf180mcu_fd_sc_mcu7t5v0__fillcap_64
Xclkbuf_4_4_0_sys_clk_i clkbuf_0_sys_clk_i/Z clkbuf_4_4_0_sys_clk_i/Z VDD VDD VSS
+ VSS gf180mcu_fd_sc_mcu7t5v0__clkbuf_2
XFILLER_14_481 VDD VDD VSS VSS gf180mcu_fd_sc_mcu7t5v0__fill_2
X_1962_ _1962_/D _2136_/RN _1971_/CLK _1962_/Q VDD VDD VSS VSS gf180mcu_fd_sc_mcu7t5v0__dffrnq_1
XPHY_EDGE_ROW_56_Right_56 VDD VSS gf180mcu_fd_sc_mcu7t5v0__endcap
X_1893_ _1893_/D _1895_/RN _2152_/CLK _1893_/Q VDD VDD VSS VSS gf180mcu_fd_sc_mcu7t5v0__dffsnq_1
X_0913_ _2121_/Q _1535_/A3 VDD VDD VSS VSS gf180mcu_fd_sc_mcu7t5v0__clkinv_1
XPHY_EDGE_ROW_65_Right_65 VDD VSS gf180mcu_fd_sc_mcu7t5v0__endcap
XFILLER_69_632 VDD VDD VSS VSS gf180mcu_fd_sc_mcu7t5v0__fillcap_32
XFILLER_68_131 VDD VDD VSS VSS gf180mcu_fd_sc_mcu7t5v0__fill_1
XFILLER_29_507 VDD VDD VSS VSS gf180mcu_fd_sc_mcu7t5v0__fill_2
XFILLER_96_451 VDD VDD VSS VSS gf180mcu_fd_sc_mcu7t5v0__fillcap_4
X_1327_ _1338_/A2 _1604_/A2 _1327_/B _2051_/Q _1341_/A2 VDD VDD VSS VSS gf180mcu_fd_sc_mcu7t5v0__oai211_1
X_1258_ _1294_/A1 _1259_/A2 _1258_/A3 _1294_/A4 _2163_/D VDD VDD VSS VSS gf180mcu_fd_sc_mcu7t5v0__and4_1
XFILLER_56_348 VDD VDD VSS VSS gf180mcu_fd_sc_mcu7t5v0__fill_1
XFILLER_37_562 VDD VDD VSS VSS gf180mcu_fd_sc_mcu7t5v0__fillcap_8
X_1189_ _1195_/A1 _1969_/Q _1191_/A3 _1191_/A4 _1189_/Z VDD VDD VSS VSS gf180mcu_fd_sc_mcu7t5v0__and4_1
XTAP_TAPCELL_ROW_39_579 VDD VSS gf180mcu_fd_sc_mcu7t5v0__filltie
XPHY_EDGE_ROW_74_Right_74 VDD VSS gf180mcu_fd_sc_mcu7t5v0__endcap
XFILLER_33_48 VDD VDD VSS VSS gf180mcu_fd_sc_mcu7t5v0__fillcap_16
XTAP_TAPCELL_ROW_22_424 VDD VSS gf180mcu_fd_sc_mcu7t5v0__filltie
Xudma_uart_top_507 data_rx_o[31] VDD VDD VSS VSS gf180mcu_fd_sc_mcu7t5v0__tiel
XPHY_EDGE_ROW_83_Right_83 VDD VSS gf180mcu_fd_sc_mcu7t5v0__endcap
XFILLER_58_34 VDD VDD VSS VSS gf180mcu_fd_sc_mcu7t5v0__fill_1
XFILLER_87_473 VDD VDD VSS VSS gf180mcu_fd_sc_mcu7t5v0__fill_2
XFILLER_59_142 VDD VDD VSS VSS gf180mcu_fd_sc_mcu7t5v0__fillcap_8
XFILLER_87_484 VDD VDD VSS VSS gf180mcu_fd_sc_mcu7t5v0__fillcap_4
XFILLER_47_348 VDD VDD VSS VSS gf180mcu_fd_sc_mcu7t5v0__fill_2
XFILLER_15_201 VDD VDD VSS VSS gf180mcu_fd_sc_mcu7t5v0__fill_2
XFILLER_28_584 VDD VDD VSS VSS gf180mcu_fd_sc_mcu7t5v0__fillcap_8
XPHY_EDGE_ROW_92_Right_92 VDD VSS gf180mcu_fd_sc_mcu7t5v0__endcap
XFILLER_70_395 VDD VDD VSS VSS gf180mcu_fd_sc_mcu7t5v0__fillcap_4
XFILLER_11_451 VDD VDD VSS VSS gf180mcu_fd_sc_mcu7t5v0__fill_1
XFILLER_30_259 VDD VDD VSS VSS gf180mcu_fd_sc_mcu7t5v0__fill_2
XFILLER_7_400 VDD VDD VSS VSS gf180mcu_fd_sc_mcu7t5v0__fill_1
Xwire364 wire364/I cfg_tx_startaddr_o[10] VDD VDD VSS VSS gf180mcu_fd_sc_mcu7t5v0__clkbuf_3
Xwire375 wire375/I cfg_tx_size_o[15] VDD VDD VSS VSS gf180mcu_fd_sc_mcu7t5v0__clkbuf_3
Xwire386 wire386/I cfg_rx_startaddr_o[8] VDD VDD VSS VSS gf180mcu_fd_sc_mcu7t5v0__clkbuf_3
Xwire397 wire397/I cfg_rx_size_o[9] VDD VDD VSS VSS gf180mcu_fd_sc_mcu7t5v0__clkbuf_3
X_2161_ _2161_/D _2161_/RN _2172_/CLK _2161_/Q VDD VDD VSS VSS gf180mcu_fd_sc_mcu7t5v0__dffrnq_1
XFILLER_19_551 VDD VDD VSS VSS gf180mcu_fd_sc_mcu7t5v0__fillcap_8
X_2092_ _2092_/D _2092_/RN _2133_/CLK _2092_/Q VDD VDD VSS VSS gf180mcu_fd_sc_mcu7t5v0__dffrnq_1
X_1112_ _1154_/A1 _2168_/Q _1136_/A1 VDD VDD VSS VSS gf180mcu_fd_sc_mcu7t5v0__nand2_1
XTAP_TAPCELL_ROW_88_1046 VDD VSS gf180mcu_fd_sc_mcu7t5v0__filltie
XFILLER_93_465 VDD VDD VSS VSS gf180mcu_fd_sc_mcu7t5v0__fill_1
XFILLER_19_562 VDD VDD VSS VSS gf180mcu_fd_sc_mcu7t5v0__fillcap_8
X_1043_ _1045_/C _2109_/D VDD VDD VSS VSS gf180mcu_fd_sc_mcu7t5v0__clkinv_1
XTAP_TAPCELL_ROW_64_825 VDD VSS gf180mcu_fd_sc_mcu7t5v0__filltie
XFILLER_93_498 VDD VDD VSS VSS gf180mcu_fd_sc_mcu7t5v0__fill_1
XFILLER_21_204 VDD VDD VSS VSS gf180mcu_fd_sc_mcu7t5v0__fillcap_4
X_1945_ _1945_/D _1954_/RN _1955_/CLK _1945_/Q VDD VDD VSS VSS gf180mcu_fd_sc_mcu7t5v0__dffrnq_1
XFILLER_9_72 VDD VDD VSS VSS gf180mcu_fd_sc_mcu7t5v0__fillcap_4
X_1876_ _1876_/D _1887_/RN _2171_/CLK _1876_/Q VDD VDD VSS VSS gf180mcu_fd_sc_mcu7t5v0__dffrnq_1
Xclkbuf_5_25__f_periph_clk_i clkbuf_4_12_0_periph_clk_i/Z _2172_/CLK VDD VDD VSS VSS
+ gf180mcu_fd_sc_mcu7t5v0__clkbuf_16
XFILLER_72_605 VDD VDD VSS VSS gf180mcu_fd_sc_mcu7t5v0__fill_1
XFILLER_56_123 VDD VDD VSS VSS gf180mcu_fd_sc_mcu7t5v0__fill_2
XFILLER_71_137 VDD VDD VSS VSS gf180mcu_fd_sc_mcu7t5v0__fill_2
XFILLER_25_576 VDD VDD VSS VSS gf180mcu_fd_sc_mcu7t5v0__fill_1
XFILLER_80_693 VDD VDD VSS VSS gf180mcu_fd_sc_mcu7t5v0__fill_1
XFILLER_52_384 VDD VDD VSS VSS gf180mcu_fd_sc_mcu7t5v0__fill_1
XFILLER_40_524 VDD VDD VSS VSS gf180mcu_fd_sc_mcu7t5v0__fill_1
XFILLER_20_270 VDD VDD VSS VSS gf180mcu_fd_sc_mcu7t5v0__fillcap_32
XFILLER_48_613 VDD VDD VSS VSS gf180mcu_fd_sc_mcu7t5v0__fillcap_4
XFILLER_75_476 VDD VDD VSS VSS gf180mcu_fd_sc_mcu7t5v0__fillcap_8
XFILLER_63_616 VDD VDD VSS VSS gf180mcu_fd_sc_mcu7t5v0__fillcap_8
XFILLER_62_104 VDD VDD VSS VSS gf180mcu_fd_sc_mcu7t5v0__fill_1
XFILLER_90_457 VDD VDD VSS VSS gf180mcu_fd_sc_mcu7t5v0__fillcap_8
XFILLER_62_115 VDD VDD VSS VSS gf180mcu_fd_sc_mcu7t5v0__fill_1
XFILLER_62_159 VDD VDD VSS VSS gf180mcu_fd_sc_mcu7t5v0__fill_1
X_1730_ _1730_/A1 _1730_/A2 _1730_/B _2065_/D VDD VDD VSS VSS gf180mcu_fd_sc_mcu7t5v0__aoi21_1
X_1661_ _2031_/Q input9/Z _1664_/S _2031_/D VDD VDD VSS VSS gf180mcu_fd_sc_mcu7t5v0__mux2_2
X_1592_ _1966_/Q input20/Z _1596_/S _1966_/D VDD VDD VSS VSS gf180mcu_fd_sc_mcu7t5v0__mux2_2
XFILLER_98_546 VDD VDD VSS VSS gf180mcu_fd_sc_mcu7t5v0__fillcap_32
XFILLER_39_602 VDD VDD VSS VSS gf180mcu_fd_sc_mcu7t5v0__fillcap_4
X_2144_ _2144_/D _2160_/RN _2172_/CLK _2144_/Q VDD VDD VSS VSS gf180mcu_fd_sc_mcu7t5v0__dffrnq_1
XTAP_TAPCELL_ROW_49_674 VDD VSS gf180mcu_fd_sc_mcu7t5v0__filltie
XFILLER_66_465 VDD VDD VSS VSS gf180mcu_fd_sc_mcu7t5v0__fillcap_4
XFILLER_53_104 VDD VDD VSS VSS gf180mcu_fd_sc_mcu7t5v0__fillcap_4
X_2075_ _2075_/D _2139_/RN _2129_/CLK _2075_/Q VDD VDD VSS VSS gf180mcu_fd_sc_mcu7t5v0__dffsnq_1
XFILLER_53_126 VDD VDD VSS VSS gf180mcu_fd_sc_mcu7t5v0__fill_2
X_1026_ _2088_/Q _2133_/Q _1026_/Z VDD VDD VSS VSS gf180mcu_fd_sc_mcu7t5v0__xor2_1
XFILLER_22_524 VDD VDD VSS VSS gf180mcu_fd_sc_mcu7t5v0__fill_1
XFILLER_62_693 VDD VDD VSS VSS gf180mcu_fd_sc_mcu7t5v0__fill_1
X_1928_ _1928_/D _1948_/RN clkload4/I _2122_/D VDD VDD VSS VSS gf180mcu_fd_sc_mcu7t5v0__dffrnq_1
X_1859_ _1859_/D _1887_/RN _2058_/CLK _1859_/Q VDD VDD VSS VSS gf180mcu_fd_sc_mcu7t5v0__dffrnq_1
XFILLER_1_417 VDD VDD VSS VSS gf180mcu_fd_sc_mcu7t5v0__fill_2
XFILLER_89_535 VDD VDD VSS VSS gf180mcu_fd_sc_mcu7t5v0__fill_2
XFILLER_89_524 VDD VDD VSS VSS gf180mcu_fd_sc_mcu7t5v0__fill_2
XFILLER_29_134 VDD VDD VSS VSS gf180mcu_fd_sc_mcu7t5v0__fillcap_4
XTAP_TAPCELL_ROW_4_255 VDD VSS gf180mcu_fd_sc_mcu7t5v0__filltie
XFILLER_72_446 VDD VDD VSS VSS gf180mcu_fd_sc_mcu7t5v0__fill_1
XFILLER_44_159 VDD VDD VSS VSS gf180mcu_fd_sc_mcu7t5v0__fillcap_16
XFILLER_44_148 VDD VDD VSS VSS gf180mcu_fd_sc_mcu7t5v0__fill_2
XTAP_TAPCELL_ROW_83_997 VDD VSS gf180mcu_fd_sc_mcu7t5v0__filltie
XFILLER_53_693 VDD VDD VSS VSS gf180mcu_fd_sc_mcu7t5v0__fill_1
Xclkbuf_4_9_0_periph_clk_i clkbuf_0_periph_clk_i/Z clkbuf_4_9_0_periph_clk_i/Z VDD
+ VDD VSS VSS gf180mcu_fd_sc_mcu7t5v0__clkbuf_2
XFILLER_40_387 VDD VDD VSS VSS gf180mcu_fd_sc_mcu7t5v0__fillcap_8
XFILLER_40_376 VDD VDD VSS VSS gf180mcu_fd_sc_mcu7t5v0__fillcap_8
XFILLER_48_454 VDD VDD VSS VSS gf180mcu_fd_sc_mcu7t5v0__fill_1
XFILLER_36_605 VDD VDD VSS VSS gf180mcu_fd_sc_mcu7t5v0__fillcap_4
XTAP_TAPCELL_ROW_85_1016 VDD VSS gf180mcu_fd_sc_mcu7t5v0__filltie
XTAP_TAPCELL_ROW_74_920 VDD VSS gf180mcu_fd_sc_mcu7t5v0__filltie
XPHY_EDGE_ROW_11_Left_110 VDD VSS gf180mcu_fd_sc_mcu7t5v0__endcap
XFILLER_16_384 VDD VDD VSS VSS gf180mcu_fd_sc_mcu7t5v0__fill_1
XTAP_TAPCELL_ROW_18_379 VDD VSS gf180mcu_fd_sc_mcu7t5v0__filltie
XFILLER_16_395 VDD VDD VSS VSS gf180mcu_fd_sc_mcu7t5v0__fill_2
X_1713_ _1713_/A1 _1713_/A2 _1714_/I0 VDD VDD VSS VSS gf180mcu_fd_sc_mcu7t5v0__nand2_1
XTAP_TAPCELL_ROW_96_1123 VDD VSS gf180mcu_fd_sc_mcu7t5v0__filltie
X_1644_ _2015_/Q input36/Z _1647_/S _2015_/D VDD VDD VSS VSS gf180mcu_fd_sc_mcu7t5v0__mux2_2
X_1575_ _1575_/I0 _1954_/Q _1576_/S _1954_/D VDD VDD VSS VSS gf180mcu_fd_sc_mcu7t5v0__mux2_2
XFILLER_86_527 VDD VDD VSS VSS gf180mcu_fd_sc_mcu7t5v0__fill_1
XTAP_TAPCELL_ROW_1_225 VDD VSS gf180mcu_fd_sc_mcu7t5v0__filltie
XFILLER_39_487 VDD VDD VSS VSS gf180mcu_fd_sc_mcu7t5v0__fill_2
XFILLER_26_104 VDD VDD VSS VSS gf180mcu_fd_sc_mcu7t5v0__fill_1
X_2127_ _2127_/D _2127_/RN _2128_/CLK _2127_/Q VDD VDD VSS VSS gf180mcu_fd_sc_mcu7t5v0__dffrnq_1
XFILLER_54_435 VDD VDD VSS VSS gf180mcu_fd_sc_mcu7t5v0__fill_2
X_2058_ _2058_/D _2161_/RN _2058_/CLK _2058_/Q VDD VDD VSS VSS gf180mcu_fd_sc_mcu7t5v0__dffsnq_1
XFILLER_54_457 VDD VDD VSS VSS gf180mcu_fd_sc_mcu7t5v0__fillcap_32
X_1009_ _1935_/Q _1934_/Q _1009_/ZN VDD VDD VSS VSS gf180mcu_fd_sc_mcu7t5v0__nand2_1
XFILLER_50_663 VDD VDD VSS VSS gf180mcu_fd_sc_mcu7t5v0__fill_2
XFILLER_10_527 VDD VDD VSS VSS gf180mcu_fd_sc_mcu7t5v0__fill_2
XFILLER_22_387 VDD VDD VSS VSS gf180mcu_fd_sc_mcu7t5v0__fillcap_32
Xmax_cap280 _1284_/A2 _1287_/A2 VDD VDD VSS VSS gf180mcu_fd_sc_mcu7t5v0__dlyb_1
XFILLER_77_549 VDD VDD VSS VSS gf180mcu_fd_sc_mcu7t5v0__fillcap_8
XFILLER_45_402 VDD VDD VSS VSS gf180mcu_fd_sc_mcu7t5v0__fill_2
XFILLER_17_104 VDD VDD VSS VSS gf180mcu_fd_sc_mcu7t5v0__fillcap_16
XFILLER_72_243 VDD VDD VSS VSS gf180mcu_fd_sc_mcu7t5v0__fill_2
XFILLER_32_107 VDD VDD VSS VSS gf180mcu_fd_sc_mcu7t5v0__fill_2
XTAP_TAPCELL_ROW_43_625 VDD VSS gf180mcu_fd_sc_mcu7t5v0__filltie
XFILLER_13_332 VDD VDD VSS VSS gf180mcu_fd_sc_mcu7t5v0__fillcap_8
XFILLER_13_398 VDD VDD VSS VSS gf180mcu_fd_sc_mcu7t5v0__fill_1
XFILLER_31_81 VDD VDD VSS VSS gf180mcu_fd_sc_mcu7t5v0__fill_2
X_1360_ _1360_/A1 _1360_/A2 _1360_/A3 _1360_/ZN VDD VDD VSS VSS gf180mcu_fd_sc_mcu7t5v0__nand3_1
XFILLER_68_505 VDD VDD VSS VSS gf180mcu_fd_sc_mcu7t5v0__fillcap_8
XTAP_TAPCELL_ROW_91_1075 VDD VSS gf180mcu_fd_sc_mcu7t5v0__filltie
X_1291_ _1291_/A1 _1291_/A2 _2172_/D VDD VDD VSS VSS gf180mcu_fd_sc_mcu7t5v0__nor2_1
XFILLER_24_608 VDD VDD VSS VSS gf180mcu_fd_sc_mcu7t5v0__fillcap_4
XFILLER_36_457 VDD VDD VSS VSS gf180mcu_fd_sc_mcu7t5v0__fillcap_16
XFILLER_51_438 VDD VDD VSS VSS gf180mcu_fd_sc_mcu7t5v0__fillcap_8
XFILLER_51_405 VDD VDD VSS VSS gf180mcu_fd_sc_mcu7t5v0__fillcap_8
X_1627_ _1999_/Q input37/Z _1627_/S _1999_/D VDD VDD VSS VSS gf180mcu_fd_sc_mcu7t5v0__mux2_2
X_1558_ _1550_/B _1938_/Q _1563_/S VDD VDD VSS VSS gf180mcu_fd_sc_mcu7t5v0__nor2_1
Xfanout326 _1332_/ZN _1404_/A2 VDD VDD VSS VSS gf180mcu_fd_sc_mcu7t5v0__dlyb_1
Xfanout337 _1333_/A1 _1195_/A3 VDD VDD VSS VSS gf180mcu_fd_sc_mcu7t5v0__dlyb_1
Xfanout348 _2155_/RN _1856_/RN VDD VDD VSS VSS gf180mcu_fd_sc_mcu7t5v0__dlyb_1
XFILLER_86_313 VDD VDD VSS VSS gf180mcu_fd_sc_mcu7t5v0__fill_2
X_1489_ _1499_/A1 _1908_/Q _1491_/B VDD VDD VSS VSS gf180mcu_fd_sc_mcu7t5v0__nand2_1
XFILLER_27_402 VDD VDD VSS VSS gf180mcu_fd_sc_mcu7t5v0__fill_2
XFILLER_36_37 VDD VDD VSS VSS gf180mcu_fd_sc_mcu7t5v0__fill_2
XFILLER_14_107 VDD VDD VSS VSS gf180mcu_fd_sc_mcu7t5v0__fillcap_4
XFILLER_6_317 VDD VDD VSS VSS gf180mcu_fd_sc_mcu7t5v0__fill_2
XFILLER_2_589 VDD VDD VSS VSS gf180mcu_fd_sc_mcu7t5v0__fillcap_4
XFILLER_58_593 VDD VDD VSS VSS gf180mcu_fd_sc_mcu7t5v0__fill_2
XFILLER_18_457 VDD VDD VSS VSS gf180mcu_fd_sc_mcu7t5v0__fillcap_32
Xclkbuf_4_3_0_sys_clk_i clkbuf_0_sys_clk_i/Z clkbuf_4_3_0_sys_clk_i/Z VDD VDD VSS
+ VSS gf180mcu_fd_sc_mcu7t5v0__clkbuf_2
XTAP_TAPCELL_ROW_28_474 VDD VSS gf180mcu_fd_sc_mcu7t5v0__filltie
XFILLER_60_279 VDD VDD VSS VSS gf180mcu_fd_sc_mcu7t5v0__fillcap_16
XFILLER_5_372 VDD VDD VSS VSS gf180mcu_fd_sc_mcu7t5v0__fill_2
X_1412_ _1861_/Q _2061_/Q _1412_/S _1861_/D VDD VDD VSS VSS gf180mcu_fd_sc_mcu7t5v0__mux2_2
X_1343_ _2039_/Q _1354_/A2 _1354_/A3 _1329_/Z _1346_/A1 VDD VDD VSS VSS gf180mcu_fd_sc_mcu7t5v0__nand4_1
X_1274_ _1274_/A1 _1280_/A1 _1274_/A3 _1300_/A2 VDD VDD VSS VSS gf180mcu_fd_sc_mcu7t5v0__nor3_1
XFILLER_83_305 VDD VDD VSS VSS gf180mcu_fd_sc_mcu7t5v0__fillcap_8
XFILLER_68_368 VDD VDD VSS VSS gf180mcu_fd_sc_mcu7t5v0__fillcap_4
XFILLER_68_357 VDD VDD VSS VSS gf180mcu_fd_sc_mcu7t5v0__fill_2
XFILLER_83_349 VDD VDD VSS VSS gf180mcu_fd_sc_mcu7t5v0__fill_1
XFILLER_36_243 VDD VDD VSS VSS gf180mcu_fd_sc_mcu7t5v0__fill_2
XFILLER_91_360 VDD VDD VSS VSS gf180mcu_fd_sc_mcu7t5v0__fillcap_4
XFILLER_51_279 VDD VDD VSS VSS gf180mcu_fd_sc_mcu7t5v0__fill_1
XTAP_TAPCELL_ROW_62_797 VDD VSS gf180mcu_fd_sc_mcu7t5v0__filltie
X_0989_ _1895_/Q _1894_/Q _1061_/A2 VDD VDD VSS VSS gf180mcu_fd_sc_mcu7t5v0__nand2_1
XFILLER_87_688 VDD VDD VSS VSS gf180mcu_fd_sc_mcu7t5v0__fillcap_4
XFILLER_27_232 VDD VDD VSS VSS gf180mcu_fd_sc_mcu7t5v0__fill_2
XFILLER_67_390 VDD VDD VSS VSS gf180mcu_fd_sc_mcu7t5v0__fill_2
XFILLER_27_276 VDD VDD VSS VSS gf180mcu_fd_sc_mcu7t5v0__fillcap_4
XFILLER_27_298 VDD VDD VSS VSS gf180mcu_fd_sc_mcu7t5v0__fillcap_4
XTAP_TAPCELL_ROW_53_720 VDD VSS gf180mcu_fd_sc_mcu7t5v0__filltie
XFILLER_82_382 VDD VDD VSS VSS gf180mcu_fd_sc_mcu7t5v0__fill_2
XFILLER_70_522 VDD VDD VSS VSS gf180mcu_fd_sc_mcu7t5v0__fill_2
XFILLER_11_688 VDD VDD VSS VSS gf180mcu_fd_sc_mcu7t5v0__fillcap_4
XFILLER_97_419 VDD VDD VSS VSS gf180mcu_fd_sc_mcu7t5v0__fill_1
XFILLER_2_397 VDD VDD VSS VSS gf180mcu_fd_sc_mcu7t5v0__fillcap_8
XFILLER_65_349 VDD VDD VSS VSS gf180mcu_fd_sc_mcu7t5v0__fill_1
XFILLER_80_319 VDD VDD VSS VSS gf180mcu_fd_sc_mcu7t5v0__fill_1
XFILLER_21_408 VDD VDD VSS VSS gf180mcu_fd_sc_mcu7t5v0__fillcap_8
X_1961_ _1961_/D _2136_/RN _1961_/CLK _1961_/Q VDD VDD VSS VSS gf180mcu_fd_sc_mcu7t5v0__dffrnq_1
X_1892_ _1892_/D _1895_/RN _2152_/CLK _1892_/Q VDD VDD VSS VSS gf180mcu_fd_sc_mcu7t5v0__dffsnq_1
X_0912_ _2119_/Q _1532_/A1 VDD VDD VSS VSS gf180mcu_fd_sc_mcu7t5v0__clkinv_1
XFILLER_6_681 VDD VDD VSS VSS gf180mcu_fd_sc_mcu7t5v0__fill_1
XFILLER_52_2 VDD VDD VSS VSS gf180mcu_fd_sc_mcu7t5v0__fillcap_32
XFILLER_5_180 VDD VDD VSS VSS gf180mcu_fd_sc_mcu7t5v0__fillcap_4
X_1326_ input3/Z _0907_/I _1173_/Z _1333_/A1 _1685_/A1 VDD VDD VSS VSS gf180mcu_fd_sc_mcu7t5v0__nand4_1
XPHY_EDGE_ROW_3_Left_102 VDD VSS gf180mcu_fd_sc_mcu7t5v0__endcap
XFILLER_96_463 VDD VDD VSS VSS gf180mcu_fd_sc_mcu7t5v0__fill_1
XFILLER_69_688 VDD VDD VSS VSS gf180mcu_fd_sc_mcu7t5v0__fillcap_4
XFILLER_56_338 VDD VDD VSS VSS gf180mcu_fd_sc_mcu7t5v0__fill_2
XFILLER_37_541 VDD VDD VSS VSS gf180mcu_fd_sc_mcu7t5v0__fill_1
X_1257_ _1257_/A1 _1257_/A2 _1258_/A3 VDD VDD VSS VSS gf180mcu_fd_sc_mcu7t5v0__nand2_1
XTAP_TAPCELL_ROW_67_845 VDD VSS gf180mcu_fd_sc_mcu7t5v0__filltie
X_1188_ _1191_/A1 _1968_/Q _1191_/A3 _1191_/A4 _1188_/Z VDD VDD VSS VSS gf180mcu_fd_sc_mcu7t5v0__and4_1
XFILLER_92_691 VDD VDD VSS VSS gf180mcu_fd_sc_mcu7t5v0__fill_2
XFILLER_33_16 VDD VDD VSS VSS gf180mcu_fd_sc_mcu7t5v0__fillcap_32
XTAP_TAPCELL_ROW_22_425 VDD VSS gf180mcu_fd_sc_mcu7t5v0__filltie
XFILLER_20_430 VDD VDD VSS VSS gf180mcu_fd_sc_mcu7t5v0__fillcap_8
XPHY_EDGE_ROW_49_Left_148 VDD VSS gf180mcu_fd_sc_mcu7t5v0__endcap
Xudma_uart_top_508 data_tx_datasize_o[0] VDD VDD VSS VSS gf180mcu_fd_sc_mcu7t5v0__tiel
XFILLER_87_430 VDD VDD VSS VSS gf180mcu_fd_sc_mcu7t5v0__fill_1
XPHY_EDGE_ROW_58_Left_157 VDD VSS gf180mcu_fd_sc_mcu7t5v0__endcap
XFILLER_59_187 VDD VDD VSS VSS gf180mcu_fd_sc_mcu7t5v0__fillcap_16
XFILLER_74_34 VDD VDD VSS VSS gf180mcu_fd_sc_mcu7t5v0__fill_1
Xclkbuf_5_12__f_sys_clk_i clkbuf_4_6_0_sys_clk_i/Z _2191_/CLK VDD VDD VSS VSS gf180mcu_fd_sc_mcu7t5v0__clkbuf_16
XFILLER_83_680 VDD VDD VSS VSS gf180mcu_fd_sc_mcu7t5v0__fillcap_8
XFILLER_15_268 VDD VDD VSS VSS gf180mcu_fd_sc_mcu7t5v0__fillcap_8
XPHY_EDGE_ROW_67_Left_166 VDD VSS gf180mcu_fd_sc_mcu7t5v0__endcap
XFILLER_23_290 VDD VDD VSS VSS gf180mcu_fd_sc_mcu7t5v0__fill_1
Xwire354 wire354/I cfg_tx_startaddr_o[9] VDD VDD VSS VSS gf180mcu_fd_sc_mcu7t5v0__clkbuf_3
Xwire365 wire365/I cfg_tx_startaddr_o[0] VDD VDD VSS VSS gf180mcu_fd_sc_mcu7t5v0__clkbuf_3
Xwire376 wire376/I cfg_tx_size_o[14] VDD VDD VSS VSS gf180mcu_fd_sc_mcu7t5v0__clkbuf_3
Xwire387 wire387/I cfg_rx_startaddr_o[7] VDD VDD VSS VSS gf180mcu_fd_sc_mcu7t5v0__clkbuf_3
Xwire398 wire398/I cfg_rx_size_o[8] VDD VDD VSS VSS gf180mcu_fd_sc_mcu7t5v0__clkbuf_3
XFILLER_7_478 VDD VDD VSS VSS gf180mcu_fd_sc_mcu7t5v0__fillcap_8
XPHY_EDGE_ROW_76_Left_175 VDD VSS gf180mcu_fd_sc_mcu7t5v0__endcap
X_2160_ _2160_/D _2160_/RN _2172_/CLK _2160_/Q VDD VDD VSS VSS gf180mcu_fd_sc_mcu7t5v0__dffrnq_1
Xclkbuf_5_12__f_periph_clk_i clkbuf_4_6_0_periph_clk_i/Z _1887_/CLK VDD VDD VSS VSS
+ gf180mcu_fd_sc_mcu7t5v0__clkbuf_16
XFILLER_78_496 VDD VDD VSS VSS gf180mcu_fd_sc_mcu7t5v0__fill_2
X_2091_ _2091_/D _2092_/RN _2095_/CLK _2091_/Q VDD VDD VSS VSS gf180mcu_fd_sc_mcu7t5v0__dffrnq_1
X_1111_ _1253_/A2 _2087_/Q _1149_/A4 VDD VDD VSS VSS gf180mcu_fd_sc_mcu7t5v0__nand2_1
XTAP_TAPCELL_ROW_88_1047 VDD VSS gf180mcu_fd_sc_mcu7t5v0__filltie
XFILLER_66_647 VDD VDD VSS VSS gf180mcu_fd_sc_mcu7t5v0__fillcap_16
XFILLER_19_574 VDD VDD VSS VSS gf180mcu_fd_sc_mcu7t5v0__fill_1
X_1042_ _2070_/Q _2068_/Q _1756_/A1 _1045_/C VDD VDD VSS VSS gf180mcu_fd_sc_mcu7t5v0__nor3_1
XFILLER_93_488 VDD VDD VSS VSS gf180mcu_fd_sc_mcu7t5v0__fill_2
XFILLER_80_127 VDD VDD VSS VSS gf180mcu_fd_sc_mcu7t5v0__fill_1
XFILLER_74_691 VDD VDD VSS VSS gf180mcu_fd_sc_mcu7t5v0__fill_2
XPHY_EDGE_ROW_85_Left_184 VDD VSS gf180mcu_fd_sc_mcu7t5v0__endcap
XFILLER_61_352 VDD VDD VSS VSS gf180mcu_fd_sc_mcu7t5v0__fillcap_4
XTAP_TAPCELL_ROW_72_892 VDD VSS gf180mcu_fd_sc_mcu7t5v0__filltie
X_1944_ _1944_/D _1957_/RN _1952_/CLK _1944_/Q VDD VDD VSS VSS gf180mcu_fd_sc_mcu7t5v0__dffrnq_1
X_1875_ _1875_/D _1887_/RN _2171_/CLK _1875_/Q VDD VDD VSS VSS gf180mcu_fd_sc_mcu7t5v0__dffrnq_1
XPHY_EDGE_ROW_94_Left_193 VDD VSS gf180mcu_fd_sc_mcu7t5v0__endcap
XFILLER_28_16 VDD VDD VSS VSS gf180mcu_fd_sc_mcu7t5v0__fillcap_8
XFILLER_57_625 VDD VDD VSS VSS gf180mcu_fd_sc_mcu7t5v0__fillcap_4
XFILLER_56_102 VDD VDD VSS VSS gf180mcu_fd_sc_mcu7t5v0__fill_2
X_1309_ _1884_/Q _1876_/Q _1868_/Q _1860_/Q _1312_/S0 _1312_/S1 _1309_/Z VDD VDD VSS
+ VSS gf180mcu_fd_sc_mcu7t5v0__mux4_1
XFILLER_25_500 VDD VDD VSS VSS gf180mcu_fd_sc_mcu7t5v0__fillcap_4
XFILLER_71_105 VDD VDD VSS VSS gf180mcu_fd_sc_mcu7t5v0__fillcap_32
XFILLER_65_680 VDD VDD VSS VSS gf180mcu_fd_sc_mcu7t5v0__fillcap_8
XFILLER_25_544 VDD VDD VSS VSS gf180mcu_fd_sc_mcu7t5v0__fill_1
XFILLER_80_661 VDD VDD VSS VSS gf180mcu_fd_sc_mcu7t5v0__fillcap_4
XFILLER_80_683 VDD VDD VSS VSS gf180mcu_fd_sc_mcu7t5v0__fillcap_8
XFILLER_0_621 VDD VDD VSS VSS gf180mcu_fd_sc_mcu7t5v0__fillcap_16
XTAP_TAPCELL_ROW_7_275 VDD VSS gf180mcu_fd_sc_mcu7t5v0__filltie
XFILLER_75_411 VDD VDD VSS VSS gf180mcu_fd_sc_mcu7t5v0__fill_1
XFILLER_87_282 VDD VDD VSS VSS gf180mcu_fd_sc_mcu7t5v0__fillcap_4
XFILLER_85_66 VDD VDD VSS VSS gf180mcu_fd_sc_mcu7t5v0__fillcap_4
XFILLER_75_488 VDD VDD VSS VSS gf180mcu_fd_sc_mcu7t5v0__fill_2
XFILLER_63_628 VDD VDD VSS VSS gf180mcu_fd_sc_mcu7t5v0__fill_2
XFILLER_16_533 VDD VDD VSS VSS gf180mcu_fd_sc_mcu7t5v0__fill_1
XFILLER_56_691 VDD VDD VSS VSS gf180mcu_fd_sc_mcu7t5v0__fill_2
XFILLER_11_282 VDD VDD VSS VSS gf180mcu_fd_sc_mcu7t5v0__fillcap_8
X_1660_ _2030_/Q input8/Z _1664_/S _2030_/D VDD VDD VSS VSS gf180mcu_fd_sc_mcu7t5v0__mux2_2
X_1591_ _1965_/Q input19/Z _1596_/S _1965_/D VDD VDD VSS VSS gf180mcu_fd_sc_mcu7t5v0__mux2_2
XFILLER_50_80 VDD VDD VSS VSS gf180mcu_fd_sc_mcu7t5v0__fill_2
XFILLER_3_492 VDD VDD VSS VSS gf180mcu_fd_sc_mcu7t5v0__fillcap_4
XFILLER_38_102 VDD VDD VSS VSS gf180mcu_fd_sc_mcu7t5v0__fill_2
XFILLER_78_271 VDD VDD VSS VSS gf180mcu_fd_sc_mcu7t5v0__fill_2
XFILLER_15_2 VDD VDD VSS VSS gf180mcu_fd_sc_mcu7t5v0__fill_2
X_2143_ _2143_/D _2160_/RN _2158_/CLK _2143_/Q VDD VDD VSS VSS gf180mcu_fd_sc_mcu7t5v0__dffrnq_1
XTAP_TAPCELL_ROW_77_940 VDD VSS gf180mcu_fd_sc_mcu7t5v0__filltie
XTAP_TAPCELL_ROW_49_675 VDD VSS gf180mcu_fd_sc_mcu7t5v0__filltie
X_2074_ _2074_/D _2136_/RN _2134_/CLK _2074_/Q VDD VDD VSS VSS gf180mcu_fd_sc_mcu7t5v0__dffsnq_1
X_1025_ _2090_/Q _2135_/Q _1025_/Z VDD VDD VSS VSS gf180mcu_fd_sc_mcu7t5v0__xor2_1
XFILLER_62_661 VDD VDD VSS VSS gf180mcu_fd_sc_mcu7t5v0__fillcap_4
XFILLER_62_683 VDD VDD VSS VSS gf180mcu_fd_sc_mcu7t5v0__fillcap_8
XFILLER_61_160 VDD VDD VSS VSS gf180mcu_fd_sc_mcu7t5v0__fill_2
XTAP_TAPCELL_ROW_32_520 VDD VSS gf180mcu_fd_sc_mcu7t5v0__filltie
X_1927_ _1927_/D _1927_/RN _1955_/CLK _1927_/Q VDD VDD VSS VSS gf180mcu_fd_sc_mcu7t5v0__dffrnq_1
X_1858_ _1858_/D _1887_/RN _2057_/CLK _1858_/Q VDD VDD VSS VSS gf180mcu_fd_sc_mcu7t5v0__dffrnq_1
X_1789_ _1813_/A1 _1789_/A2 _1915_/Q _1790_/A3 VDD VDD VSS VSS gf180mcu_fd_sc_mcu7t5v0__nand3_1
XFILLER_89_547 VDD VDD VSS VSS gf180mcu_fd_sc_mcu7t5v0__fillcap_8
XFILLER_29_102 VDD VDD VSS VSS gf180mcu_fd_sc_mcu7t5v0__fillcap_32
XFILLER_69_282 VDD VDD VSS VSS gf180mcu_fd_sc_mcu7t5v0__fill_2
XFILLER_57_422 VDD VDD VSS VSS gf180mcu_fd_sc_mcu7t5v0__fillcap_8
XFILLER_84_241 VDD VDD VSS VSS gf180mcu_fd_sc_mcu7t5v0__fillcap_4
XFILLER_25_352 VDD VDD VSS VSS gf180mcu_fd_sc_mcu7t5v0__fillcap_8
XTAP_TAPCELL_ROW_83_998 VDD VSS gf180mcu_fd_sc_mcu7t5v0__filltie
XFILLER_13_569 VDD VDD VSS VSS gf180mcu_fd_sc_mcu7t5v0__fillcap_8
XFILLER_21_580 VDD VDD VSS VSS gf180mcu_fd_sc_mcu7t5v0__fill_1
XFILLER_40_399 VDD VDD VSS VSS gf180mcu_fd_sc_mcu7t5v0__fill_2
XFILLER_88_591 VDD VDD VSS VSS gf180mcu_fd_sc_mcu7t5v0__fillcap_4
XFILLER_29_92 VDD VDD VSS VSS gf180mcu_fd_sc_mcu7t5v0__fill_2
XTAP_TAPCELL_ROW_85_1017 VDD VSS gf180mcu_fd_sc_mcu7t5v0__filltie
XFILLER_16_341 VDD VDD VSS VSS gf180mcu_fd_sc_mcu7t5v0__fill_1
XTAP_TAPCELL_ROW_46_645 VDD VSS gf180mcu_fd_sc_mcu7t5v0__filltie
X_1712_ _1738_/A1 _1739_/A1 _2159_/Q _1713_/A2 VDD VDD VSS VSS gf180mcu_fd_sc_mcu7t5v0__nand3_1
XTAP_TAPCELL_ROW_96_1124 VDD VSS gf180mcu_fd_sc_mcu7t5v0__filltie
XANTENNA_1 input4/Z VDD VDD VSS VSS gf180mcu_fd_sc_mcu7t5v0__antenna
X_1643_ _2014_/Q input35/Z _1647_/S _2014_/D VDD VDD VSS VSS gf180mcu_fd_sc_mcu7t5v0__mux2_2
XFILLER_6_30 VDD VDD VSS VSS gf180mcu_fd_sc_mcu7t5v0__fillcap_4
X_1574_ _1574_/I0 _1953_/Q _1576_/S _1953_/D VDD VDD VSS VSS gf180mcu_fd_sc_mcu7t5v0__mux2_2
X_2126_ _2126_/D _2126_/RN clkload4/I _2126_/Q VDD VDD VSS VSS gf180mcu_fd_sc_mcu7t5v0__dffrnq_1
XTAP_TAPCELL_ROW_1_226 VDD VSS gf180mcu_fd_sc_mcu7t5v0__filltie
X_2057_ _2057_/D _2188_/RN _2057_/CLK _2057_/Q VDD VDD VSS VSS gf180mcu_fd_sc_mcu7t5v0__dffsnq_1
XFILLER_54_447 VDD VDD VSS VSS gf180mcu_fd_sc_mcu7t5v0__fillcap_8
X_1008_ _1932_/Q _1935_/Q _1014_/A2 VDD VDD VSS VSS gf180mcu_fd_sc_mcu7t5v0__nand2_1
XFILLER_34_193 VDD VDD VSS VSS gf180mcu_fd_sc_mcu7t5v0__fillcap_32
XTAP_TAPCELL_ROW_80_968 VDD VSS gf180mcu_fd_sc_mcu7t5v0__filltie
XFILLER_10_517 VDD VDD VSS VSS gf180mcu_fd_sc_mcu7t5v0__fillcap_8
Xclkbuf_5_0__f_sys_clk_i clkbuf_4_0_0_sys_clk_i/Z _2034_/CLK VDD VDD VSS VSS gf180mcu_fd_sc_mcu7t5v0__clkbuf_16
Xmax_cap281 _1246_/A3 _1242_/A2 VDD VDD VSS VSS gf180mcu_fd_sc_mcu7t5v0__dlyb_1
Xclkbuf_4_2_0_sys_clk_i clkbuf_0_sys_clk_i/Z clkbuf_4_2_0_sys_clk_i/Z VDD VDD VSS
+ VSS gf180mcu_fd_sc_mcu7t5v0__clkbuf_2
XFILLER_72_255 VDD VDD VSS VSS gf180mcu_fd_sc_mcu7t5v0__fillcap_16
XFILLER_82_34 VDD VDD VSS VSS gf180mcu_fd_sc_mcu7t5v0__fill_1
XFILLER_15_72 VDD VDD VSS VSS gf180mcu_fd_sc_mcu7t5v0__fillcap_16
XFILLER_5_554 VDD VDD VSS VSS gf180mcu_fd_sc_mcu7t5v0__fillcap_4
XTAP_TAPCELL_ROW_91_1076 VDD VSS gf180mcu_fd_sc_mcu7t5v0__filltie
X_1290_ _1290_/A1 _1290_/A2 _1164_/I _1292_/A2 _1291_/A1 VDD VDD VSS VSS gf180mcu_fd_sc_mcu7t5v0__nand4_1
XFILLER_48_230 VDD VDD VSS VSS gf180mcu_fd_sc_mcu7t5v0__fill_1
XTAP_TAPCELL_ROW_59_770 VDD VSS gf180mcu_fd_sc_mcu7t5v0__filltie
XFILLER_76_594 VDD VDD VSS VSS gf180mcu_fd_sc_mcu7t5v0__fill_1
XFILLER_63_200 VDD VDD VSS VSS gf180mcu_fd_sc_mcu7t5v0__fill_1
XFILLER_91_542 VDD VDD VSS VSS gf180mcu_fd_sc_mcu7t5v0__fillcap_16
XFILLER_91_531 VDD VDD VSS VSS gf180mcu_fd_sc_mcu7t5v0__fillcap_4
XFILLER_63_266 VDD VDD VSS VSS gf180mcu_fd_sc_mcu7t5v0__fill_2
XFILLER_51_417 VDD VDD VSS VSS gf180mcu_fd_sc_mcu7t5v0__fill_2
XTAP_TAPCELL_ROW_14_350 VDD VSS gf180mcu_fd_sc_mcu7t5v0__filltie
XFILLER_82_2 VDD VDD VSS VSS gf180mcu_fd_sc_mcu7t5v0__fillcap_32
X_1626_ _1998_/Q input36/Z _1627_/S _1998_/D VDD VDD VSS VSS gf180mcu_fd_sc_mcu7t5v0__mux2_2
X_1557_ _1557_/A1 _1938_/Q _1580_/A3 _1573_/S VDD VDD VSS VSS gf180mcu_fd_sc_mcu7t5v0__nand3_1
Xfanout316 _1609_/S _1611_/S VDD VDD VSS VSS gf180mcu_fd_sc_mcu7t5v0__buf_1
Xfanout327 _1396_/B1 _1393_/B1 VDD VDD VSS VSS gf180mcu_fd_sc_mcu7t5v0__clkbuf_2
Xfanout338 _1177_/ZN _1333_/A1 VDD VDD VSS VSS gf180mcu_fd_sc_mcu7t5v0__dlyb_1
X_1488_ _1497_/A1 _1519_/A2 _1488_/B _1907_/D VDD VDD VSS VSS gf180mcu_fd_sc_mcu7t5v0__oai21_1
XFILLER_86_325 VDD VDD VSS VSS gf180mcu_fd_sc_mcu7t5v0__fill_2
XFILLER_82_520 VDD VDD VSS VSS gf180mcu_fd_sc_mcu7t5v0__fillcap_4
XFILLER_67_583 VDD VDD VSS VSS gf180mcu_fd_sc_mcu7t5v0__fillcap_8
X_2109_ _2109_/D _2127_/RN clkload6/I _2109_/Q VDD VDD VSS VSS gf180mcu_fd_sc_mcu7t5v0__dffrnq_1
XFILLER_82_597 VDD VDD VSS VSS gf180mcu_fd_sc_mcu7t5v0__fill_1
Xclkbuf_5_17__f_sys_clk_i clkbuf_4_8_0_sys_clk_i/Z _1949_/CLK VDD VDD VSS VSS gf180mcu_fd_sc_mcu7t5v0__clkbuf_16
XPHY_EDGE_ROW_30_Left_129 VDD VSS gf180mcu_fd_sc_mcu7t5v0__endcap
XFILLER_52_37 VDD VDD VSS VSS gf180mcu_fd_sc_mcu7t5v0__fillcap_8
XFILLER_10_314 VDD VDD VSS VSS gf180mcu_fd_sc_mcu7t5v0__fill_1
XFILLER_77_358 VDD VDD VSS VSS gf180mcu_fd_sc_mcu7t5v0__fill_1
XFILLER_92_317 VDD VDD VSS VSS gf180mcu_fd_sc_mcu7t5v0__fillcap_16
XTAP_TAPCELL_ROW_56_740 VDD VSS gf180mcu_fd_sc_mcu7t5v0__filltie
XFILLER_93_66 VDD VDD VSS VSS gf180mcu_fd_sc_mcu7t5v0__fillcap_4
XFILLER_45_222 VDD VDD VSS VSS gf180mcu_fd_sc_mcu7t5v0__fill_1
XFILLER_33_428 VDD VDD VSS VSS gf180mcu_fd_sc_mcu7t5v0__fill_1
XTAP_TAPCELL_ROW_28_475 VDD VSS gf180mcu_fd_sc_mcu7t5v0__filltie
XFILLER_60_247 VDD VDD VSS VSS gf180mcu_fd_sc_mcu7t5v0__fillcap_32
XFILLER_45_288 VDD VDD VSS VSS gf180mcu_fd_sc_mcu7t5v0__fill_2
XTAP_TAPCELL_ROW_11_320 VDD VSS gf180mcu_fd_sc_mcu7t5v0__filltie
X_1411_ _1860_/Q _2060_/Q _1414_/S _1860_/D VDD VDD VSS VSS gf180mcu_fd_sc_mcu7t5v0__mux2_2
XFILLER_68_303 VDD VDD VSS VSS gf180mcu_fd_sc_mcu7t5v0__fill_1
X_1342_ _0968_/Z _1604_/A3 _0907_/I _1173_/Z _1670_/A1 VDD VDD VSS VSS gf180mcu_fd_sc_mcu7t5v0__nand4_1
X_1273_ _1280_/A1 _1280_/A4 _1276_/A2 VDD VDD VSS VSS gf180mcu_fd_sc_mcu7t5v0__nand2_1
XFILLER_96_667 VDD VDD VSS VSS gf180mcu_fd_sc_mcu7t5v0__fillcap_16
XFILLER_49_594 VDD VDD VSS VSS gf180mcu_fd_sc_mcu7t5v0__fillcap_16
XFILLER_24_439 VDD VDD VSS VSS gf180mcu_fd_sc_mcu7t5v0__fill_2
XFILLER_64_597 VDD VDD VSS VSS gf180mcu_fd_sc_mcu7t5v0__fillcap_64
XFILLER_51_269 VDD VDD VSS VSS gf180mcu_fd_sc_mcu7t5v0__fillcap_8
XTAP_TAPCELL_ROW_62_798 VDD VSS gf180mcu_fd_sc_mcu7t5v0__filltie
X_0988_ _0990_/A1 _2147_/Q _1892_/Q _1895_/Q _0991_/A3 VDD VDD VSS VSS gf180mcu_fd_sc_mcu7t5v0__nand4_1
X_1609_ input32/Z _1982_/Q _1609_/S _1982_/D VDD VDD VSS VSS gf180mcu_fd_sc_mcu7t5v0__mux2_2
XFILLER_86_177 VDD VDD VSS VSS gf180mcu_fd_sc_mcu7t5v0__fillcap_64
XFILLER_74_339 VDD VDD VSS VSS gf180mcu_fd_sc_mcu7t5v0__fillcap_8
XFILLER_74_317 VDD VDD VSS VSS gf180mcu_fd_sc_mcu7t5v0__fillcap_8
XFILLER_47_48 VDD VDD VSS VSS gf180mcu_fd_sc_mcu7t5v0__fillcap_16
XFILLER_15_417 VDD VDD VSS VSS gf180mcu_fd_sc_mcu7t5v0__fill_2
XFILLER_42_247 VDD VDD VSS VSS gf180mcu_fd_sc_mcu7t5v0__fillcap_16
XFILLER_11_623 VDD VDD VSS VSS gf180mcu_fd_sc_mcu7t5v0__fillcap_4
XFILLER_70_589 VDD VDD VSS VSS gf180mcu_fd_sc_mcu7t5v0__fillcap_4
XFILLER_50_291 VDD VDD VSS VSS gf180mcu_fd_sc_mcu7t5v0__fill_2
XFILLER_10_177 VDD VDD VSS VSS gf180mcu_fd_sc_mcu7t5v0__fill_2
Xclkbuf_5_20__f_periph_clk_i clkbuf_4_10_0_periph_clk_i/Z _2138_/CLK VDD VDD VSS VSS
+ gf180mcu_fd_sc_mcu7t5v0__clkbuf_16
XFILLER_78_601 VDD VDD VSS VSS gf180mcu_fd_sc_mcu7t5v0__fill_2
XFILLER_2_387 VDD VDD VSS VSS gf180mcu_fd_sc_mcu7t5v0__fillcap_4
XFILLER_77_111 VDD VDD VSS VSS gf180mcu_fd_sc_mcu7t5v0__fill_1
XFILLER_78_667 VDD VDD VSS VSS gf180mcu_fd_sc_mcu7t5v0__fillcap_16
XFILLER_93_626 VDD VDD VSS VSS gf180mcu_fd_sc_mcu7t5v0__fillcap_4
XFILLER_18_244 VDD VDD VSS VSS gf180mcu_fd_sc_mcu7t5v0__fill_1
XFILLER_18_299 VDD VDD VSS VSS gf180mcu_fd_sc_mcu7t5v0__fillcap_4
XFILLER_46_597 VDD VDD VSS VSS gf180mcu_fd_sc_mcu7t5v0__fillcap_8
XFILLER_14_483 VDD VDD VSS VSS gf180mcu_fd_sc_mcu7t5v0__fill_1
X_1960_ _1960_/D _2130_/RN _1971_/CLK _1960_/Q VDD VDD VSS VSS gf180mcu_fd_sc_mcu7t5v0__dffrnq_1
X_1891_ _1891_/D fanout346/Z _2156_/CLK _2153_/D VDD VDD VSS VSS gf180mcu_fd_sc_mcu7t5v0__dffsnq_1
X_0911_ _2118_/Q _1534_/A1 VDD VDD VSS VSS gf180mcu_fd_sc_mcu7t5v0__clkinv_1
XFILLER_29_509 VDD VDD VSS VSS gf180mcu_fd_sc_mcu7t5v0__fill_1
X_1325_ _0906_/I _0907_/I _1173_/Z _1333_/A1 _1325_/Z VDD VDD VSS VSS gf180mcu_fd_sc_mcu7t5v0__and4_1
XFILLER_68_177 VDD VDD VSS VSS gf180mcu_fd_sc_mcu7t5v0__fillcap_32
XFILLER_68_166 VDD VDD VSS VSS gf180mcu_fd_sc_mcu7t5v0__fillcap_8
XFILLER_56_317 VDD VDD VSS VSS gf180mcu_fd_sc_mcu7t5v0__fillcap_8
X_1256_ _2161_/Q _2162_/Q _2163_/Q _1259_/A2 VDD VDD VSS VSS gf180mcu_fd_sc_mcu7t5v0__nand3_1
XTAP_TAPCELL_ROW_67_846 VDD VSS gf180mcu_fd_sc_mcu7t5v0__filltie
X_1187_ _1191_/A1 _1967_/Q _1191_/A3 _1191_/A4 _1187_/Z VDD VDD VSS VSS gf180mcu_fd_sc_mcu7t5v0__and4_1
XFILLER_64_383 VDD VDD VSS VSS gf180mcu_fd_sc_mcu7t5v0__fill_2
XFILLER_24_247 VDD VDD VSS VSS gf180mcu_fd_sc_mcu7t5v0__fillcap_64
XFILLER_52_589 VDD VDD VSS VSS gf180mcu_fd_sc_mcu7t5v0__fillcap_4
XFILLER_20_442 VDD VDD VSS VSS gf180mcu_fd_sc_mcu7t5v0__fill_2
XTAP_TAPCELL_ROW_22_426 VDD VSS gf180mcu_fd_sc_mcu7t5v0__filltie
Xudma_uart_top_509 data_tx_datasize_o[1] VDD VDD VSS VSS gf180mcu_fd_sc_mcu7t5v0__tiel
XFILLER_59_155 VDD VDD VSS VSS gf180mcu_fd_sc_mcu7t5v0__fillcap_32
XFILLER_87_475 VDD VDD VSS VSS gf180mcu_fd_sc_mcu7t5v0__fill_1
XFILLER_75_626 VDD VDD VSS VSS gf180mcu_fd_sc_mcu7t5v0__fillcap_4
XFILLER_62_309 VDD VDD VSS VSS gf180mcu_fd_sc_mcu7t5v0__fillcap_4
XFILLER_55_361 VDD VDD VSS VSS gf180mcu_fd_sc_mcu7t5v0__fillcap_16
XFILLER_28_597 VDD VDD VSS VSS gf180mcu_fd_sc_mcu7t5v0__fillcap_8
XTAP_TAPCELL_ROW_38_570 VDD VSS gf180mcu_fd_sc_mcu7t5v0__filltie
XFILLER_83_692 VDD VDD VSS VSS gf180mcu_fd_sc_mcu7t5v0__fill_2
XFILLER_43_512 VDD VDD VSS VSS gf180mcu_fd_sc_mcu7t5v0__fill_2
XFILLER_43_578 VDD VDD VSS VSS gf180mcu_fd_sc_mcu7t5v0__fillcap_4
XFILLER_90_34 VDD VDD VSS VSS gf180mcu_fd_sc_mcu7t5v0__fill_1
XFILLER_11_442 VDD VDD VSS VSS gf180mcu_fd_sc_mcu7t5v0__fill_1
XFILLER_11_464 VDD VDD VSS VSS gf180mcu_fd_sc_mcu7t5v0__fill_1
XFILLER_23_72 VDD VDD VSS VSS gf180mcu_fd_sc_mcu7t5v0__fillcap_64
Xwire300 wire300/I cfg_data_o[25] VDD VDD VSS VSS gf180mcu_fd_sc_mcu7t5v0__clkbuf_3
Xwire355 wire355/I cfg_tx_startaddr_o[8] VDD VDD VSS VSS gf180mcu_fd_sc_mcu7t5v0__clkbuf_3
Xwire366 wire366/I cfg_tx_size_o[9] VDD VDD VSS VSS gf180mcu_fd_sc_mcu7t5v0__clkbuf_3
Xwire377 wire377/I cfg_tx_size_o[13] VDD VDD VSS VSS gf180mcu_fd_sc_mcu7t5v0__clkbuf_3
Xwire388 wire388/I cfg_rx_startaddr_o[6] VDD VDD VSS VSS gf180mcu_fd_sc_mcu7t5v0__clkbuf_3
Xwire399 wire399/I cfg_rx_size_o[7] VDD VDD VSS VSS gf180mcu_fd_sc_mcu7t5v0__clkbuf_3
XFILLER_97_206 VDD VDD VSS VSS gf180mcu_fd_sc_mcu7t5v0__fillcap_4
Xload_slew349 _1856_/RN _2156_/RN VDD VDD VSS VSS gf180mcu_fd_sc_mcu7t5v0__clkbuf_3
X_1110_ _1251_/A1 _1110_/A2 _1107_/Z _1290_/A1 VDD VDD VSS VSS gf180mcu_fd_sc_mcu7t5v0__nand3_1
XFILLER_38_317 VDD VDD VSS VSS gf180mcu_fd_sc_mcu7t5v0__fillcap_16
X_2090_ _2090_/D _2098_/RN _2095_/CLK _2090_/Q VDD VDD VSS VSS gf180mcu_fd_sc_mcu7t5v0__dffrnq_1
XTAP_TAPCELL_ROW_88_1048 VDD VSS gf180mcu_fd_sc_mcu7t5v0__filltie
X_1041_ _2068_/Q _1756_/A1 _1746_/B VDD VDD VSS VSS gf180mcu_fd_sc_mcu7t5v0__nor2_1
XTAP_TAPCELL_ROW_64_816 VDD VSS gf180mcu_fd_sc_mcu7t5v0__filltie
XTAP_TAPCELL_ROW_72_893 VDD VSS gf180mcu_fd_sc_mcu7t5v0__filltie
X_1943_ _1943_/D _1951_/RN _1954_/CLK _1943_/Q VDD VDD VSS VSS gf180mcu_fd_sc_mcu7t5v0__dffrnq_1
X_1874_ _1874_/D _1874_/RN _2058_/CLK _1874_/Q VDD VDD VSS VSS gf180mcu_fd_sc_mcu7t5v0__dffrnq_1
Xclkbuf_5_5__f_sys_clk_i clkbuf_4_2_0_sys_clk_i/Z _2000_/CLK VDD VDD VSS VSS gf180mcu_fd_sc_mcu7t5v0__clkbuf_16
X_1308_ _1883_/Q _1875_/Q _1867_/Q _1859_/Q _1312_/S0 _1312_/S1 _1308_/Z VDD VDD VSS
+ VSS gf180mcu_fd_sc_mcu7t5v0__mux4_1
XFILLER_56_125 VDD VDD VSS VSS gf180mcu_fd_sc_mcu7t5v0__fill_1
X_1239_ _2142_/Q _2143_/Q _1240_/A4 VDD VDD VSS VSS gf180mcu_fd_sc_mcu7t5v0__nand2_1
XFILLER_44_309 VDD VDD VSS VSS gf180mcu_fd_sc_mcu7t5v0__fillcap_4
XFILLER_71_139 VDD VDD VSS VSS gf180mcu_fd_sc_mcu7t5v0__fill_1
XFILLER_65_692 VDD VDD VSS VSS gf180mcu_fd_sc_mcu7t5v0__fill_2
XFILLER_52_331 VDD VDD VSS VSS gf180mcu_fd_sc_mcu7t5v0__fill_1
XFILLER_60_37 VDD VDD VSS VSS gf180mcu_fd_sc_mcu7t5v0__fillcap_16
XTAP_TAPCELL_ROW_7_276 VDD VSS gf180mcu_fd_sc_mcu7t5v0__filltie
XFILLER_28_383 VDD VDD VSS VSS gf180mcu_fd_sc_mcu7t5v0__fill_2
XFILLER_31_504 VDD VDD VSS VSS gf180mcu_fd_sc_mcu7t5v0__fill_2
XFILLER_11_272 VDD VDD VSS VSS gf180mcu_fd_sc_mcu7t5v0__fillcap_8
XTAP_TAPCELL_ROW_41_598 VDD VSS gf180mcu_fd_sc_mcu7t5v0__filltie
XFILLER_11_294 VDD VDD VSS VSS gf180mcu_fd_sc_mcu7t5v0__fill_2
X_1590_ _1964_/Q input18/Z _1601_/S _1964_/D VDD VDD VSS VSS gf180mcu_fd_sc_mcu7t5v0__mux2_2
XFILLER_98_526 VDD VDD VSS VSS gf180mcu_fd_sc_mcu7t5v0__fillcap_16
X_2142_ _2142_/D _2160_/RN _2142_/CLK _2142_/Q VDD VDD VSS VSS gf180mcu_fd_sc_mcu7t5v0__dffrnq_1
XTAP_TAPCELL_ROW_77_941 VDD VSS gf180mcu_fd_sc_mcu7t5v0__filltie
X_2073_ _2073_/D _2082_/RN _2138_/CLK _2073_/Q VDD VDD VSS VSS gf180mcu_fd_sc_mcu7t5v0__dffsnq_1
XTAP_TAPCELL_ROW_49_676 VDD VSS gf180mcu_fd_sc_mcu7t5v0__filltie
XFILLER_19_361 VDD VDD VSS VSS gf180mcu_fd_sc_mcu7t5v0__fillcap_16
X_1024_ _2086_/Q _2131_/Q _1038_/A2 VDD VDD VSS VSS gf180mcu_fd_sc_mcu7t5v0__xnor2_1
XTAP_TAPCELL_ROW_32_521 VDD VSS gf180mcu_fd_sc_mcu7t5v0__filltie
XFILLER_30_592 VDD VDD VSS VSS gf180mcu_fd_sc_mcu7t5v0__fill_2
X_1926_ _1926_/D _1926_/RN _1971_/CLK _1926_/Q VDD VDD VSS VSS gf180mcu_fd_sc_mcu7t5v0__dffrnq_1
X_1857_ _1857_/D _2156_/RN _2154_/CLK _1857_/Q VDD VDD VSS VSS gf180mcu_fd_sc_mcu7t5v0__dffrnq_1
X_1788_ _1821_/A2 _1923_/Q _1790_/A2 VDD VDD VSS VSS gf180mcu_fd_sc_mcu7t5v0__nand2_1
XFILLER_1_419 VDD VDD VSS VSS gf180mcu_fd_sc_mcu7t5v0__fill_1
XFILLER_89_537 VDD VDD VSS VSS gf180mcu_fd_sc_mcu7t5v0__fill_1
XFILLER_89_526 VDD VDD VSS VSS gf180mcu_fd_sc_mcu7t5v0__fill_1
XFILLER_89_559 VDD VDD VSS VSS gf180mcu_fd_sc_mcu7t5v0__fill_1
XTAP_TAPCELL_ROW_4_246 VDD VSS gf180mcu_fd_sc_mcu7t5v0__filltie
Xclkbuf_4_1_0_sys_clk_i clkbuf_0_sys_clk_i/Z clkbuf_4_1_0_sys_clk_i/Z VDD VDD VSS
+ VSS gf180mcu_fd_sc_mcu7t5v0__clkbuf_2
XFILLER_57_489 VDD VDD VSS VSS gf180mcu_fd_sc_mcu7t5v0__fill_1
XTAP_TAPCELL_ROW_83_999 VDD VSS gf180mcu_fd_sc_mcu7t5v0__filltie
XFILLER_52_161 VDD VDD VSS VSS gf180mcu_fd_sc_mcu7t5v0__fill_2
XFILLER_13_548 VDD VDD VSS VSS gf180mcu_fd_sc_mcu7t5v0__fillcap_8
XFILLER_4_235 VDD VDD VSS VSS gf180mcu_fd_sc_mcu7t5v0__fillcap_4
Xclkbuf_5_24__f_sys_clk_i clkbuf_4_12_0_sys_clk_i/Z _2037_/CLK VDD VDD VSS VSS gf180mcu_fd_sc_mcu7t5v0__clkbuf_16
XFILLER_96_22 VDD VDD VSS VSS gf180mcu_fd_sc_mcu7t5v0__fillcap_8
XFILLER_0_474 VDD VDD VSS VSS gf180mcu_fd_sc_mcu7t5v0__fill_2
XFILLER_48_445 VDD VDD VSS VSS gf180mcu_fd_sc_mcu7t5v0__fill_1
XTAP_TAPCELL_ROW_85_1018 VDD VSS gf180mcu_fd_sc_mcu7t5v0__filltie
XTAP_TAPCELL_ROW_74_911 VDD VSS gf180mcu_fd_sc_mcu7t5v0__filltie
XTAP_TAPCELL_ROW_46_646 VDD VSS gf180mcu_fd_sc_mcu7t5v0__filltie
XFILLER_44_640 VDD VDD VSS VSS gf180mcu_fd_sc_mcu7t5v0__fill_2
XFILLER_16_364 VDD VDD VSS VSS gf180mcu_fd_sc_mcu7t5v0__fillcap_4
XFILLER_16_397 VDD VDD VSS VSS gf180mcu_fd_sc_mcu7t5v0__fill_1
XFILLER_71_492 VDD VDD VSS VSS gf180mcu_fd_sc_mcu7t5v0__fillcap_16
XFILLER_31_367 VDD VDD VSS VSS gf180mcu_fd_sc_mcu7t5v0__fillcap_4
X_1711_ _2101_/Q _2102_/Q _2061_/Q _1713_/A1 VDD VDD VSS VSS gf180mcu_fd_sc_mcu7t5v0__oai21_1
XTAP_TAPCELL_ROW_96_1125 VDD VSS gf180mcu_fd_sc_mcu7t5v0__filltie
XFILLER_61_80 VDD VDD VSS VSS gf180mcu_fd_sc_mcu7t5v0__fillcap_16
XANTENNA_2 input111/Z VDD VDD VSS VSS gf180mcu_fd_sc_mcu7t5v0__antenna
X_1642_ _2013_/Q input34/Z _1642_/S _2013_/D VDD VDD VSS VSS gf180mcu_fd_sc_mcu7t5v0__mux2_2
X_1573_ _1573_/I0 _1952_/Q _1573_/S _1952_/D VDD VDD VSS VSS gf180mcu_fd_sc_mcu7t5v0__mux2_2
XFILLER_98_301 VDD VDD VSS VSS gf180mcu_fd_sc_mcu7t5v0__fillcap_4
X_2125_ _2125_/D _2123_/RN _2125_/CLK _2125_/Q VDD VDD VSS VSS gf180mcu_fd_sc_mcu7t5v0__dffsnq_1
XFILLER_81_212 VDD VDD VSS VSS gf180mcu_fd_sc_mcu7t5v0__fillcap_16
XFILLER_66_297 VDD VDD VSS VSS gf180mcu_fd_sc_mcu7t5v0__fillcap_8
XFILLER_54_437 VDD VDD VSS VSS gf180mcu_fd_sc_mcu7t5v0__fill_1
XFILLER_39_489 VDD VDD VSS VSS gf180mcu_fd_sc_mcu7t5v0__fill_1
XFILLER_19_180 VDD VDD VSS VSS gf180mcu_fd_sc_mcu7t5v0__fillcap_16
X_2056_ _2056_/D _2188_/RN _2057_/CLK _2056_/Q VDD VDD VSS VSS gf180mcu_fd_sc_mcu7t5v0__dffsnq_1
X_1007_ _1932_/Q _1933_/Q _1813_/A1 VDD VDD VSS VSS gf180mcu_fd_sc_mcu7t5v0__nand2_1
XFILLER_81_278 VDD VDD VSS VSS gf180mcu_fd_sc_mcu7t5v0__fill_2
XFILLER_22_312 VDD VDD VSS VSS gf180mcu_fd_sc_mcu7t5v0__fill_2
XTAP_TAPCELL_ROW_80_969 VDD VSS gf180mcu_fd_sc_mcu7t5v0__filltie
XTAP_TAPCELL_ROW_17_370 VDD VSS gf180mcu_fd_sc_mcu7t5v0__filltie
XFILLER_50_621 VDD VDD VSS VSS gf180mcu_fd_sc_mcu7t5v0__fill_2
X_1909_ _1909_/D _1918_/RN _1961_/CLK _1909_/Q VDD VDD VSS VSS gf180mcu_fd_sc_mcu7t5v0__dffrnq_1
XFILLER_57_220 VDD VDD VSS VSS gf180mcu_fd_sc_mcu7t5v0__fillcap_8
XFILLER_85_562 VDD VDD VSS VSS gf180mcu_fd_sc_mcu7t5v0__fillcap_4
XFILLER_53_492 VDD VDD VSS VSS gf180mcu_fd_sc_mcu7t5v0__fill_1
XFILLER_53_470 VDD VDD VSS VSS gf180mcu_fd_sc_mcu7t5v0__fillcap_8
XFILLER_41_610 VDD VDD VSS VSS gf180mcu_fd_sc_mcu7t5v0__fill_2
XTAP_TAPCELL_ROW_51_693 VDD VSS gf180mcu_fd_sc_mcu7t5v0__filltie
XFILLER_31_50 VDD VDD VSS VSS gf180mcu_fd_sc_mcu7t5v0__fillcap_8
XFILLER_5_500 VDD VDD VSS VSS gf180mcu_fd_sc_mcu7t5v0__fillcap_4
XFILLER_31_72 VDD VDD VSS VSS gf180mcu_fd_sc_mcu7t5v0__fillcap_4
XFILLER_5_577 VDD VDD VSS VSS gf180mcu_fd_sc_mcu7t5v0__fill_2
XTAP_TAPCELL_ROW_91_1077 VDD VSS gf180mcu_fd_sc_mcu7t5v0__filltie
XFILLER_95_304 VDD VDD VSS VSS gf180mcu_fd_sc_mcu7t5v0__fillcap_4
XFILLER_95_337 VDD VDD VSS VSS gf180mcu_fd_sc_mcu7t5v0__fill_2
Xclkbuf_4_5_0_periph_clk_i clkbuf_0_periph_clk_i/Z clkbuf_4_5_0_periph_clk_i/Z VDD
+ VDD VSS VSS gf180mcu_fd_sc_mcu7t5v0__clkbuf_2
XTAP_TAPCELL_ROW_59_771 VDD VSS gf180mcu_fd_sc_mcu7t5v0__filltie
XFILLER_63_278 VDD VDD VSS VSS gf180mcu_fd_sc_mcu7t5v0__fill_2
XFILLER_44_481 VDD VDD VSS VSS gf180mcu_fd_sc_mcu7t5v0__fillcap_4
XFILLER_31_120 VDD VDD VSS VSS gf180mcu_fd_sc_mcu7t5v0__fill_2
XFILLER_31_142 VDD VDD VSS VSS gf180mcu_fd_sc_mcu7t5v0__fillcap_16
XFILLER_8_360 VDD VDD VSS VSS gf180mcu_fd_sc_mcu7t5v0__fillcap_16
X_1625_ _1997_/Q input35/Z _1633_/S _1997_/D VDD VDD VSS VSS gf180mcu_fd_sc_mcu7t5v0__mux2_2
X_1556_ _1556_/A1 _1554_/Z _1556_/B1 _1556_/B2 _1937_/D VDD VDD VSS VSS gf180mcu_fd_sc_mcu7t5v0__oai22_1
Xfanout328 _1313_/Z _1829_/A3 VDD VDD VSS VSS gf180mcu_fd_sc_mcu7t5v0__dlyb_1
X_1487_ _1511_/B _1464_/Z _1511_/C _1519_/A2 VDD VDD VSS VSS gf180mcu_fd_sc_mcu7t5v0__nand3_1
XFILLER_67_562 VDD VDD VSS VSS gf180mcu_fd_sc_mcu7t5v0__fillcap_8
XFILLER_67_595 VDD VDD VSS VSS gf180mcu_fd_sc_mcu7t5v0__fill_1
XFILLER_36_39 VDD VDD VSS VSS gf180mcu_fd_sc_mcu7t5v0__fill_1
X_2108_ _2108_/D _2108_/RN _2108_/CLK _2108_/Q VDD VDD VSS VSS gf180mcu_fd_sc_mcu7t5v0__dffrnq_1
XFILLER_39_297 VDD VDD VSS VSS gf180mcu_fd_sc_mcu7t5v0__fillcap_16
X_2039_ _2039_/D _2185_/RN _2116_/CLK _2039_/Q VDD VDD VSS VSS gf180mcu_fd_sc_mcu7t5v0__dffrnq_1
XFILLER_6_319 VDD VDD VSS VSS gf180mcu_fd_sc_mcu7t5v0__fill_1
XTAP_TAPCELL_ROW_20_398 VDD VSS gf180mcu_fd_sc_mcu7t5v0__filltie
XFILLER_89_142 VDD VDD VSS VSS gf180mcu_fd_sc_mcu7t5v0__fillcap_64
XTAP_TAPCELL_ROW_56_741 VDD VSS gf180mcu_fd_sc_mcu7t5v0__filltie
XFILLER_45_212 VDD VDD VSS VSS gf180mcu_fd_sc_mcu7t5v0__fillcap_8
XFILLER_60_204 VDD VDD VSS VSS gf180mcu_fd_sc_mcu7t5v0__fill_2
XFILLER_45_256 VDD VDD VSS VSS gf180mcu_fd_sc_mcu7t5v0__fillcap_16
XTAP_TAPCELL_ROW_28_476 VDD VSS gf180mcu_fd_sc_mcu7t5v0__filltie
XFILLER_60_215 VDD VDD VSS VSS gf180mcu_fd_sc_mcu7t5v0__fillcap_16
XFILLER_13_120 VDD VDD VSS VSS gf180mcu_fd_sc_mcu7t5v0__fillcap_8
XFILLER_13_142 VDD VDD VSS VSS gf180mcu_fd_sc_mcu7t5v0__fill_1
XFILLER_14_687 VDD VDD VSS VSS gf180mcu_fd_sc_mcu7t5v0__fill_1
XTAP_TAPCELL_ROW_11_321 VDD VSS gf180mcu_fd_sc_mcu7t5v0__filltie
XFILLER_5_330 VDD VDD VSS VSS gf180mcu_fd_sc_mcu7t5v0__fillcap_4
XFILLER_5_352 VDD VDD VSS VSS gf180mcu_fd_sc_mcu7t5v0__fill_1
X_1410_ _1859_/Q _2059_/Q _1414_/S _1859_/D VDD VDD VSS VSS gf180mcu_fd_sc_mcu7t5v0__mux2_2
X_1341_ _1341_/A1 _1341_/A2 _1347_/A2 VDD VDD VSS VSS gf180mcu_fd_sc_mcu7t5v0__nand2_1
XFILLER_3_54 VDD VDD VSS VSS gf180mcu_fd_sc_mcu7t5v0__fill_1
X_1272_ _1294_/A1 _1272_/A2 _1280_/A4 _1294_/A4 _2167_/D VDD VDD VSS VSS gf180mcu_fd_sc_mcu7t5v0__and4_1
XFILLER_68_359 VDD VDD VSS VSS gf180mcu_fd_sc_mcu7t5v0__fill_1
XFILLER_49_540 VDD VDD VSS VSS gf180mcu_fd_sc_mcu7t5v0__fillcap_16
XFILLER_49_562 VDD VDD VSS VSS gf180mcu_fd_sc_mcu7t5v0__fillcap_32
XFILLER_76_381 VDD VDD VSS VSS gf180mcu_fd_sc_mcu7t5v0__fillcap_4
XFILLER_64_587 VDD VDD VSS VSS gf180mcu_fd_sc_mcu7t5v0__fillcap_8
XFILLER_51_204 VDD VDD VSS VSS gf180mcu_fd_sc_mcu7t5v0__fillcap_4
XFILLER_17_492 VDD VDD VSS VSS gf180mcu_fd_sc_mcu7t5v0__fillcap_4
XTAP_TAPCELL_ROW_62_799 VDD VSS gf180mcu_fd_sc_mcu7t5v0__filltie
XFILLER_20_646 VDD VDD VSS VSS gf180mcu_fd_sc_mcu7t5v0__fillcap_4
X_0987_ _1892_/Q _1893_/Q _0987_/A3 _0991_/A2 VDD VDD VSS VSS gf180mcu_fd_sc_mcu7t5v0__nand3_1
XFILLER_9_680 VDD VDD VSS VSS gf180mcu_fd_sc_mcu7t5v0__fillcap_8
X_1608_ input31/Z _1981_/Q _1609_/S _1981_/D VDD VDD VSS VSS gf180mcu_fd_sc_mcu7t5v0__mux2_2
X_1539_ _1539_/A1 _1539_/A2 _1816_/A1 VDD VDD VSS VSS gf180mcu_fd_sc_mcu7t5v0__nor2_1
XFILLER_86_101 VDD VDD VSS VSS gf180mcu_fd_sc_mcu7t5v0__fillcap_4
XFILLER_27_212 VDD VDD VSS VSS gf180mcu_fd_sc_mcu7t5v0__fillcap_16
XFILLER_70_502 VDD VDD VSS VSS gf180mcu_fd_sc_mcu7t5v0__fillcap_16
XFILLER_82_384 VDD VDD VSS VSS gf180mcu_fd_sc_mcu7t5v0__fill_1
XFILLER_70_524 VDD VDD VSS VSS gf180mcu_fd_sc_mcu7t5v0__fill_1
XTAP_TAPCELL_ROW_25_446 VDD VSS gf180mcu_fd_sc_mcu7t5v0__filltie
XFILLER_10_101 VDD VDD VSS VSS gf180mcu_fd_sc_mcu7t5v0__fillcap_4
XFILLER_88_34 VDD VDD VSS VSS gf180mcu_fd_sc_mcu7t5v0__fill_1
XFILLER_5_2 VDD VDD VSS VSS gf180mcu_fd_sc_mcu7t5v0__fillcap_32
XFILLER_77_123 VDD VDD VSS VSS gf180mcu_fd_sc_mcu7t5v0__fillcap_16
XFILLER_77_189 VDD VDD VSS VSS gf180mcu_fd_sc_mcu7t5v0__fill_1
XFILLER_18_234 VDD VDD VSS VSS gf180mcu_fd_sc_mcu7t5v0__fillcap_8
XFILLER_46_521 VDD VDD VSS VSS gf180mcu_fd_sc_mcu7t5v0__fillcap_4
XPHY_EDGE_ROW_16_Right_16 VDD VSS gf180mcu_fd_sc_mcu7t5v0__endcap
XFILLER_14_473 VDD VDD VSS VSS gf180mcu_fd_sc_mcu7t5v0__fillcap_8
X_0910_ _1957_/Q _1580_/A1 VDD VDD VSS VSS gf180mcu_fd_sc_mcu7t5v0__clkinv_1
X_1890_ _1890_/D fanout346/Z _2156_/CLK _2152_/D VDD VDD VSS VSS gf180mcu_fd_sc_mcu7t5v0__dffsnq_1
XPHY_EDGE_ROW_25_Right_25 VDD VSS gf180mcu_fd_sc_mcu7t5v0__endcap
X_1324_ _1604_/A3 _1604_/A4 _1338_/A2 _1327_/B VDD VDD VSS VSS gf180mcu_fd_sc_mcu7t5v0__nor3_1
XFILLER_68_123 VDD VDD VSS VSS gf180mcu_fd_sc_mcu7t5v0__fillcap_8
XFILLER_56_329 VDD VDD VSS VSS gf180mcu_fd_sc_mcu7t5v0__fill_1
X_1255_ _1294_/A1 _1255_/A2 _1257_/A2 _1294_/A4 _2162_/D VDD VDD VSS VSS gf180mcu_fd_sc_mcu7t5v0__and4_1
XTAP_TAPCELL_ROW_67_847 VDD VSS gf180mcu_fd_sc_mcu7t5v0__filltie
XPHY_EDGE_ROW_34_Right_34 VDD VSS gf180mcu_fd_sc_mcu7t5v0__endcap
XFILLER_77_690 VDD VDD VSS VSS gf180mcu_fd_sc_mcu7t5v0__fillcap_4
X_1186_ _1191_/A1 _1966_/Q _1191_/A3 _1191_/A4 _1186_/Z VDD VDD VSS VSS gf180mcu_fd_sc_mcu7t5v0__and4_1
XFILLER_92_693 VDD VDD VSS VSS gf180mcu_fd_sc_mcu7t5v0__fill_1
XFILLER_52_524 VDD VDD VSS VSS gf180mcu_fd_sc_mcu7t5v0__fill_1
XFILLER_52_546 VDD VDD VSS VSS gf180mcu_fd_sc_mcu7t5v0__fill_1
XPHY_EDGE_ROW_43_Right_43 VDD VSS gf180mcu_fd_sc_mcu7t5v0__endcap
XTAP_TAPCELL_ROW_30_493 VDD VSS gf180mcu_fd_sc_mcu7t5v0__filltie
XFILLER_58_37 VDD VDD VSS VSS gf180mcu_fd_sc_mcu7t5v0__fillcap_64
Xclkbuf_5_29__f_sys_clk_i clkbuf_4_14_0_sys_clk_i/Z _1971_/CLK VDD VDD VSS VSS gf180mcu_fd_sc_mcu7t5v0__clkbuf_16
XFILLER_59_134 VDD VDD VSS VSS gf180mcu_fd_sc_mcu7t5v0__fillcap_4
XPHY_EDGE_ROW_52_Right_52 VDD VSS gf180mcu_fd_sc_mcu7t5v0__endcap
XFILLER_28_543 VDD VDD VSS VSS gf180mcu_fd_sc_mcu7t5v0__fillcap_4
XTAP_TAPCELL_ROW_38_571 VDD VSS gf180mcu_fd_sc_mcu7t5v0__filltie
XFILLER_74_69 VDD VDD VSS VSS gf180mcu_fd_sc_mcu7t5v0__fillcap_16
XFILLER_43_557 VDD VDD VSS VSS gf180mcu_fd_sc_mcu7t5v0__fill_2
XFILLER_70_387 VDD VDD VSS VSS gf180mcu_fd_sc_mcu7t5v0__fillcap_8
XPHY_EDGE_ROW_61_Right_61 VDD VSS gf180mcu_fd_sc_mcu7t5v0__endcap
Xwire301 wire301/I cfg_data_o[24] VDD VDD VSS VSS gf180mcu_fd_sc_mcu7t5v0__clkbuf_3
XFILLER_11_487 VDD VDD VSS VSS gf180mcu_fd_sc_mcu7t5v0__fill_2
Xwire356 wire356/I cfg_tx_startaddr_o[7] VDD VDD VSS VSS gf180mcu_fd_sc_mcu7t5v0__clkbuf_3
Xwire367 wire367/I cfg_tx_size_o[8] VDD VDD VSS VSS gf180mcu_fd_sc_mcu7t5v0__clkbuf_3
Xwire378 wire378/I cfg_tx_size_o[12] VDD VDD VSS VSS gf180mcu_fd_sc_mcu7t5v0__clkbuf_3
Xwire389 wire389/I cfg_rx_startaddr_o[5] VDD VDD VSS VSS gf180mcu_fd_sc_mcu7t5v0__clkbuf_3
XFILLER_3_664 VDD VDD VSS VSS gf180mcu_fd_sc_mcu7t5v0__fillcap_16
XPHY_EDGE_ROW_70_Right_70 VDD VSS gf180mcu_fd_sc_mcu7t5v0__endcap
XFILLER_78_421 VDD VDD VSS VSS gf180mcu_fd_sc_mcu7t5v0__fillcap_8
X_1040_ _2070_/Q _2068_/Q _1831_/A4 VDD VDD VSS VSS gf180mcu_fd_sc_mcu7t5v0__nor2_1
XTAP_TAPCELL_ROW_88_1049 VDD VSS gf180mcu_fd_sc_mcu7t5v0__filltie
XTAP_TAPCELL_ROW_64_817 VDD VSS gf180mcu_fd_sc_mcu7t5v0__filltie
XFILLER_80_107 VDD VDD VSS VSS gf180mcu_fd_sc_mcu7t5v0__fillcap_16
XFILLER_74_693 VDD VDD VSS VSS gf180mcu_fd_sc_mcu7t5v0__fill_1
XFILLER_73_192 VDD VDD VSS VSS gf180mcu_fd_sc_mcu7t5v0__fillcap_16
XFILLER_73_181 VDD VDD VSS VSS gf180mcu_fd_sc_mcu7t5v0__fillcap_4
XFILLER_34_579 VDD VDD VSS VSS gf180mcu_fd_sc_mcu7t5v0__fill_1
Xclkbuf_5_31__f_sys_clk_i clkbuf_4_15_0_sys_clk_i/Z clkload7/I VDD VDD VSS VSS gf180mcu_fd_sc_mcu7t5v0__clkbuf_16
XFILLER_21_229 VDD VDD VSS VSS gf180mcu_fd_sc_mcu7t5v0__fill_2
X_1942_ _1942_/D _1957_/RN _1952_/CLK _1942_/Q VDD VDD VSS VSS gf180mcu_fd_sc_mcu7t5v0__dffrnq_1
XTAP_TAPCELL_ROW_72_894 VDD VSS gf180mcu_fd_sc_mcu7t5v0__filltie
X_1873_ _1873_/D _1873_/RN _2057_/CLK _1873_/Q VDD VDD VSS VSS gf180mcu_fd_sc_mcu7t5v0__dffrnq_1
XFILLER_80_90 VDD VDD VSS VSS gf180mcu_fd_sc_mcu7t5v0__fillcap_4
XFILLER_69_454 VDD VDD VSS VSS gf180mcu_fd_sc_mcu7t5v0__fillcap_16
XFILLER_56_104 VDD VDD VSS VSS gf180mcu_fd_sc_mcu7t5v0__fill_1
Xclkbuf_4_0_0_sys_clk_i clkbuf_0_sys_clk_i/Z clkbuf_4_0_0_sys_clk_i/Z VDD VDD VSS
+ VSS gf180mcu_fd_sc_mcu7t5v0__clkbuf_2
X_1307_ _1882_/Q _1874_/Q _1866_/Q _1858_/Q _1312_/S0 _1312_/S1 _1307_/Z VDD VDD VSS
+ VSS gf180mcu_fd_sc_mcu7t5v0__mux4_1
X_1238_ _2142_/Q _1243_/A4 _2143_/Q _1241_/A2 VDD VDD VSS VSS gf180mcu_fd_sc_mcu7t5v0__aoi21_1
XFILLER_84_457 VDD VDD VSS VSS gf180mcu_fd_sc_mcu7t5v0__fillcap_4
X_1169_ _1163_/C _1169_/A2 _1169_/B1 _2186_/Q _2188_/D VDD VDD VSS VSS gf180mcu_fd_sc_mcu7t5v0__oai22_1
XFILLER_92_490 VDD VDD VSS VSS gf180mcu_fd_sc_mcu7t5v0__fillcap_4
XTAP_TAPCELL_ROW_35_541 VDD VSS gf180mcu_fd_sc_mcu7t5v0__filltie
XFILLER_52_387 VDD VDD VSS VSS gf180mcu_fd_sc_mcu7t5v0__fillcap_32
XFILLER_79_207 VDD VDD VSS VSS gf180mcu_fd_sc_mcu7t5v0__fill_2
XFILLER_69_69 VDD VDD VSS VSS gf180mcu_fd_sc_mcu7t5v0__fill_1
XFILLER_0_645 VDD VDD VSS VSS gf180mcu_fd_sc_mcu7t5v0__fill_1
XTAP_TAPCELL_ROW_7_277 VDD VSS gf180mcu_fd_sc_mcu7t5v0__filltie
XFILLER_16_502 VDD VDD VSS VSS gf180mcu_fd_sc_mcu7t5v0__fillcap_8
XFILLER_16_524 VDD VDD VSS VSS gf180mcu_fd_sc_mcu7t5v0__fill_1
XFILLER_62_107 VDD VDD VSS VSS gf180mcu_fd_sc_mcu7t5v0__fill_2
XFILLER_56_693 VDD VDD VSS VSS gf180mcu_fd_sc_mcu7t5v0__fill_1
XFILLER_55_170 VDD VDD VSS VSS gf180mcu_fd_sc_mcu7t5v0__fill_1
XFILLER_43_332 VDD VDD VSS VSS gf180mcu_fd_sc_mcu7t5v0__fillcap_4
XTAP_TAPCELL_ROW_41_599 VDD VSS gf180mcu_fd_sc_mcu7t5v0__filltie
XFILLER_15_4 VDD VDD VSS VSS gf180mcu_fd_sc_mcu7t5v0__fill_1
XFILLER_38_104 VDD VDD VSS VSS gf180mcu_fd_sc_mcu7t5v0__fill_1
X_2141_ _2141_/D _2160_/RN _2158_/CLK _2141_/Q VDD VDD VSS VSS gf180mcu_fd_sc_mcu7t5v0__dffrnq_1
XTAP_TAPCELL_ROW_77_942 VDD VSS gf180mcu_fd_sc_mcu7t5v0__filltie
XFILLER_78_273 VDD VDD VSS VSS gf180mcu_fd_sc_mcu7t5v0__fill_1
X_2072_ _2072_/D _2082_/RN _2129_/CLK _2072_/Q VDD VDD VSS VSS gf180mcu_fd_sc_mcu7t5v0__dffsnq_1
XFILLER_54_619 VDD VDD VSS VSS gf180mcu_fd_sc_mcu7t5v0__fillcap_4
XFILLER_54_608 VDD VDD VSS VSS gf180mcu_fd_sc_mcu7t5v0__fill_1
X_1023_ _2091_/Q _2136_/Q _1023_/Z VDD VDD VSS VSS gf180mcu_fd_sc_mcu7t5v0__xor2_1
XTAP_TAPCELL_ROW_49_677 VDD VSS gf180mcu_fd_sc_mcu7t5v0__filltie
XFILLER_93_298 VDD VDD VSS VSS gf180mcu_fd_sc_mcu7t5v0__fillcap_8
XFILLER_93_276 VDD VDD VSS VSS gf180mcu_fd_sc_mcu7t5v0__fillcap_4
XFILLER_34_332 VDD VDD VSS VSS gf180mcu_fd_sc_mcu7t5v0__fillcap_4
XFILLER_22_527 VDD VDD VSS VSS gf180mcu_fd_sc_mcu7t5v0__fillcap_16
XFILLER_34_387 VDD VDD VSS VSS gf180mcu_fd_sc_mcu7t5v0__fill_1
X_1925_ _1925_/D _1926_/RN _1961_/CLK _1925_/Q VDD VDD VSS VSS gf180mcu_fd_sc_mcu7t5v0__dffrnq_1
X_1856_ _1856_/D _1856_/RN _2155_/CLK _1856_/Q VDD VDD VSS VSS gf180mcu_fd_sc_mcu7t5v0__dffrnq_1
X_1787_ _1826_/A1 _1313_/Z _2075_/Q _1811_/A4 _1793_/C VDD VDD VSS VSS gf180mcu_fd_sc_mcu7t5v0__nand4_1
XTAP_TAPCELL_ROW_4_247 VDD VSS gf180mcu_fd_sc_mcu7t5v0__filltie
XFILLER_69_284 VDD VDD VSS VSS gf180mcu_fd_sc_mcu7t5v0__fill_1
XFILLER_57_413 VDD VDD VSS VSS gf180mcu_fd_sc_mcu7t5v0__fillcap_4
XPHY_EDGE_ROW_2_Right_2 VDD VSS gf180mcu_fd_sc_mcu7t5v0__endcap
XFILLER_44_107 VDD VDD VSS VSS gf180mcu_fd_sc_mcu7t5v0__fillcap_4
XFILLER_96_34 VDD VDD VSS VSS gf180mcu_fd_sc_mcu7t5v0__fill_1
XFILLER_29_72 VDD VDD VSS VSS gf180mcu_fd_sc_mcu7t5v0__fillcap_16
Xclkbuf_4_13_0_periph_clk_i clkbuf_0_periph_clk_i/Z clkbuf_4_13_0_periph_clk_i/Z VDD
+ VDD VSS VSS gf180mcu_fd_sc_mcu7t5v0__clkbuf_2
XFILLER_75_232 VDD VDD VSS VSS gf180mcu_fd_sc_mcu7t5v0__fill_2
XFILLER_48_457 VDD VDD VSS VSS gf180mcu_fd_sc_mcu7t5v0__fillcap_4
XTAP_TAPCELL_ROW_85_1019 VDD VSS gf180mcu_fd_sc_mcu7t5v0__filltie
XTAP_TAPCELL_ROW_74_912 VDD VSS gf180mcu_fd_sc_mcu7t5v0__filltie
XFILLER_16_310 VDD VDD VSS VSS gf180mcu_fd_sc_mcu7t5v0__fillcap_4
XFILLER_28_181 VDD VDD VSS VSS gf180mcu_fd_sc_mcu7t5v0__fill_2
XTAP_TAPCELL_ROW_46_647 VDD VSS gf180mcu_fd_sc_mcu7t5v0__filltie
XFILLER_75_298 VDD VDD VSS VSS gf180mcu_fd_sc_mcu7t5v0__fillcap_4
XFILLER_63_438 VDD VDD VSS VSS gf180mcu_fd_sc_mcu7t5v0__fillcap_4
XFILLER_16_376 VDD VDD VSS VSS gf180mcu_fd_sc_mcu7t5v0__fillcap_8
XFILLER_90_279 VDD VDD VSS VSS gf180mcu_fd_sc_mcu7t5v0__fillcap_4
XFILLER_71_460 VDD VDD VSS VSS gf180mcu_fd_sc_mcu7t5v0__fillcap_8
XFILLER_16_387 VDD VDD VSS VSS gf180mcu_fd_sc_mcu7t5v0__fillcap_8
XFILLER_43_162 VDD VDD VSS VSS gf180mcu_fd_sc_mcu7t5v0__fill_2
X_1710_ _2060_/Q _2059_/Q _1710_/S _2059_/D VDD VDD VSS VSS gf180mcu_fd_sc_mcu7t5v0__mux2_2
XANTENNA_3 _1248_/A2 VDD VDD VSS VSS gf180mcu_fd_sc_mcu7t5v0__antenna
X_1641_ _2012_/Q input33/Z _1641_/S _2012_/D VDD VDD VSS VSS gf180mcu_fd_sc_mcu7t5v0__mux2_2
XTAP_TAPCELL_ROW_96_1126 VDD VSS gf180mcu_fd_sc_mcu7t5v0__filltie
XFILLER_8_597 VDD VDD VSS VSS gf180mcu_fd_sc_mcu7t5v0__fillcap_64
X_1572_ _1572_/I0 _1951_/Q _1576_/S _1951_/D VDD VDD VSS VSS gf180mcu_fd_sc_mcu7t5v0__mux2_2
XFILLER_98_324 VDD VDD VSS VSS gf180mcu_fd_sc_mcu7t5v0__fill_2
XFILLER_79_582 VDD VDD VSS VSS gf180mcu_fd_sc_mcu7t5v0__fillcap_16
XFILLER_66_210 VDD VDD VSS VSS gf180mcu_fd_sc_mcu7t5v0__fillcap_8
X_2124_ _2124_/D _2123_/RN _2125_/CLK _2124_/Q VDD VDD VSS VSS gf180mcu_fd_sc_mcu7t5v0__dffsnq_1
XFILLER_26_107 VDD VDD VSS VSS gf180mcu_fd_sc_mcu7t5v0__fillcap_64
XFILLER_39_479 VDD VDD VSS VSS gf180mcu_fd_sc_mcu7t5v0__fillcap_8
X_2055_ _2055_/D _2187_/RN _2061_/CLK _2055_/Q VDD VDD VSS VSS gf180mcu_fd_sc_mcu7t5v0__dffrnq_1
X_1006_ _1511_/C _1474_/B _1934_/Q _1933_/Q _1018_/C VDD VDD VSS VSS gf180mcu_fd_sc_mcu7t5v0__oai211_1
XTAP_TAPCELL_ROW_17_371 VDD VSS gf180mcu_fd_sc_mcu7t5v0__filltie
XFILLER_50_655 VDD VDD VSS VSS gf180mcu_fd_sc_mcu7t5v0__fillcap_8
X_1908_ _1908_/D _1908_/RN _1921_/CLK _1908_/Q VDD VDD VSS VSS gf180mcu_fd_sc_mcu7t5v0__dffrnq_1
X_1839_ _1961_/Q _2086_/Q _1849_/S _2086_/D VDD VDD VSS VSS gf180mcu_fd_sc_mcu7t5v0__mux2_2
Xhold520 _2181_/Q _2180_/D VDD VDD VSS VSS gf180mcu_fd_sc_mcu7t5v0__dlyc_1
XFILLER_1_206 VDD VDD VSS VSS gf180mcu_fd_sc_mcu7t5v0__fillcap_4
Xmax_cap250 _1704_/A2 _1702_/A1 VDD VDD VSS VSS gf180mcu_fd_sc_mcu7t5v0__dlyb_1
Xmax_cap283 _1550_/A1 _1549_/A1 VDD VDD VSS VSS gf180mcu_fd_sc_mcu7t5v0__dlyb_1
XFILLER_66_37 VDD VDD VSS VSS gf180mcu_fd_sc_mcu7t5v0__fillcap_16
XFILLER_57_232 VDD VDD VSS VSS gf180mcu_fd_sc_mcu7t5v0__fill_2
XFILLER_45_416 VDD VDD VSS VSS gf180mcu_fd_sc_mcu7t5v0__fillcap_4
XFILLER_57_298 VDD VDD VSS VSS gf180mcu_fd_sc_mcu7t5v0__fillcap_16
XTAP_TAPCELL_ROW_43_617 VDD VSS gf180mcu_fd_sc_mcu7t5v0__filltie
XFILLER_53_482 VDD VDD VSS VSS gf180mcu_fd_sc_mcu7t5v0__fill_1
XFILLER_15_63 VDD VDD VSS VSS gf180mcu_fd_sc_mcu7t5v0__fillcap_4
XFILLER_15_96 VDD VDD VSS VSS gf180mcu_fd_sc_mcu7t5v0__fillcap_4
XTAP_TAPCELL_ROW_51_694 VDD VSS gf180mcu_fd_sc_mcu7t5v0__filltie
XFILLER_31_62 VDD VDD VSS VSS gf180mcu_fd_sc_mcu7t5v0__fill_1
XTAP_TAPCELL_ROW_91_1078 VDD VSS gf180mcu_fd_sc_mcu7t5v0__filltie
XTAP_TAPCELL_ROW_59_772 VDD VSS gf180mcu_fd_sc_mcu7t5v0__filltie
XFILLER_48_265 VDD VDD VSS VSS gf180mcu_fd_sc_mcu7t5v0__fillcap_4
XFILLER_51_419 VDD VDD VSS VSS gf180mcu_fd_sc_mcu7t5v0__fill_1
XFILLER_71_290 VDD VDD VSS VSS gf180mcu_fd_sc_mcu7t5v0__fillcap_8
XTAP_TAPCELL_ROW_14_341 VDD VSS gf180mcu_fd_sc_mcu7t5v0__filltie
XFILLER_68_2 VDD VDD VSS VSS gf180mcu_fd_sc_mcu7t5v0__fillcap_32
X_1624_ _1996_/Q input34/Z _1631_/S _1996_/D VDD VDD VSS VSS gf180mcu_fd_sc_mcu7t5v0__mux2_2
Xudma_uart_top_490 data_rx_o[14] VDD VDD VSS VSS gf180mcu_fd_sc_mcu7t5v0__tiel
X_1555_ _1555_/A1 _1937_/Q _1556_/B1 VDD VDD VSS VSS gf180mcu_fd_sc_mcu7t5v0__nand2_1
X_1486_ _1499_/A1 _1907_/Q _1488_/B VDD VDD VSS VSS gf180mcu_fd_sc_mcu7t5v0__nand2_1
XFILLER_86_327 VDD VDD VSS VSS gf180mcu_fd_sc_mcu7t5v0__fill_1
X_2107_ _2107_/D _2108_/RN _2108_/CLK _2108_/D VDD VDD VSS VSS gf180mcu_fd_sc_mcu7t5v0__dffrnq_1
X_2038_ _2038_/D _2185_/RN _2116_/CLK _2038_/Q VDD VDD VSS VSS gf180mcu_fd_sc_mcu7t5v0__dffrnq_1
XFILLER_82_577 VDD VDD VSS VSS gf180mcu_fd_sc_mcu7t5v0__fillcap_4
XFILLER_54_279 VDD VDD VSS VSS gf180mcu_fd_sc_mcu7t5v0__fill_2
XFILLER_23_666 VDD VDD VSS VSS gf180mcu_fd_sc_mcu7t5v0__fill_1
XTAP_TAPCELL_ROW_20_399 VDD VSS gf180mcu_fd_sc_mcu7t5v0__filltie
XFILLER_77_305 VDD VDD VSS VSS gf180mcu_fd_sc_mcu7t5v0__fill_2
XTAP_TAPCELL_ROW_56_742 VDD VSS gf180mcu_fd_sc_mcu7t5v0__filltie
XTAP_TAPCELL_ROW_28_477 VDD VSS gf180mcu_fd_sc_mcu7t5v0__filltie
XFILLER_13_132 VDD VDD VSS VSS gf180mcu_fd_sc_mcu7t5v0__fill_2
XFILLER_42_94 VDD VDD VSS VSS gf180mcu_fd_sc_mcu7t5v0__fillcap_8
XFILLER_5_364 VDD VDD VSS VSS gf180mcu_fd_sc_mcu7t5v0__fillcap_8
X_1340_ _1340_/A1 _1340_/A2 _1340_/A3 _1347_/A1 VDD VDD VSS VSS gf180mcu_fd_sc_mcu7t5v0__nand3_1
X_1271_ _2165_/Q _2166_/Q _2167_/Q _1260_/Z _1280_/A4 VDD VDD VSS VSS gf180mcu_fd_sc_mcu7t5v0__nand4_1
XFILLER_68_349 VDD VDD VSS VSS gf180mcu_fd_sc_mcu7t5v0__fillcap_8
XFILLER_64_522 VDD VDD VSS VSS gf180mcu_fd_sc_mcu7t5v0__fill_2
XFILLER_91_352 VDD VDD VSS VSS gf180mcu_fd_sc_mcu7t5v0__fillcap_8
XFILLER_24_419 VDD VDD VSS VSS gf180mcu_fd_sc_mcu7t5v0__fillcap_16
X_0986_ _0986_/A1 _2147_/Q _0987_/A3 VDD VDD VSS VSS gf180mcu_fd_sc_mcu7t5v0__nor2_1
XFILLER_9_692 VDD VDD VSS VSS gf180mcu_fd_sc_mcu7t5v0__fill_2
X_1607_ input28/Z _1980_/Q _1611_/S _1980_/D VDD VDD VSS VSS gf180mcu_fd_sc_mcu7t5v0__mux2_2
X_1538_ _1754_/B1 _1538_/A2 _1538_/A3 _1746_/B _1539_/A2 VDD VDD VSS VSS gf180mcu_fd_sc_mcu7t5v0__nand4_1
X_1469_ _1468_/Z _1901_/Q _1473_/S _1901_/D VDD VDD VSS VSS gf180mcu_fd_sc_mcu7t5v0__mux2_2
XFILLER_95_680 VDD VDD VSS VSS gf180mcu_fd_sc_mcu7t5v0__fillcap_8
XFILLER_55_544 VDD VDD VSS VSS gf180mcu_fd_sc_mcu7t5v0__fillcap_16
XFILLER_27_268 VDD VDD VSS VSS gf180mcu_fd_sc_mcu7t5v0__fillcap_8
XFILLER_15_419 VDD VDD VSS VSS gf180mcu_fd_sc_mcu7t5v0__fill_1
XTAP_TAPCELL_ROW_53_712 VDD VSS gf180mcu_fd_sc_mcu7t5v0__filltie
XTAP_TAPCELL_ROW_25_447 VDD VSS gf180mcu_fd_sc_mcu7t5v0__filltie
XFILLER_70_547 VDD VDD VSS VSS gf180mcu_fd_sc_mcu7t5v0__fill_1
XFILLER_7_629 VDD VDD VSS VSS gf180mcu_fd_sc_mcu7t5v0__fill_1
XFILLER_10_179 VDD VDD VSS VSS gf180mcu_fd_sc_mcu7t5v0__fill_1
XFILLER_2_378 VDD VDD VSS VSS gf180mcu_fd_sc_mcu7t5v0__fillcap_4
XPHY_EDGE_ROW_0_Left_99 VDD VSS gf180mcu_fd_sc_mcu7t5v0__endcap
XFILLER_77_146 VDD VDD VSS VSS gf180mcu_fd_sc_mcu7t5v0__fill_1
XFILLER_86_691 VDD VDD VSS VSS gf180mcu_fd_sc_mcu7t5v0__fill_2
XFILLER_58_382 VDD VDD VSS VSS gf180mcu_fd_sc_mcu7t5v0__fill_2
XFILLER_73_352 VDD VDD VSS VSS gf180mcu_fd_sc_mcu7t5v0__fill_1
XFILLER_18_279 VDD VDD VSS VSS gf180mcu_fd_sc_mcu7t5v0__fillcap_4
XFILLER_14_430 VDD VDD VSS VSS gf180mcu_fd_sc_mcu7t5v0__fillcap_16
XFILLER_61_558 VDD VDD VSS VSS gf180mcu_fd_sc_mcu7t5v0__fill_2
XFILLER_53_60 VDD VDD VSS VSS gf180mcu_fd_sc_mcu7t5v0__fillcap_8
XFILLER_41_282 VDD VDD VSS VSS gf180mcu_fd_sc_mcu7t5v0__fillcap_16
XFILLER_10_691 VDD VDD VSS VSS gf180mcu_fd_sc_mcu7t5v0__fill_2
X_1323_ _1604_/A4 _0906_/I _1319_/C _1319_/B _1335_/A1 VDD VDD VSS VSS gf180mcu_fd_sc_mcu7t5v0__nand4_1
X_1254_ _2161_/Q _2162_/Q _1257_/A2 VDD VDD VSS VSS gf180mcu_fd_sc_mcu7t5v0__nand2_1
XFILLER_84_617 VDD VDD VSS VSS gf180mcu_fd_sc_mcu7t5v0__fill_2
XTAP_TAPCELL_ROW_67_848 VDD VSS gf180mcu_fd_sc_mcu7t5v0__filltie
XFILLER_83_138 VDD VDD VSS VSS gf180mcu_fd_sc_mcu7t5v0__fill_2
X_1185_ _1191_/A1 _1965_/Q _1191_/A3 _1191_/A4 _1185_/Z VDD VDD VSS VSS gf180mcu_fd_sc_mcu7t5v0__and4_1
XFILLER_92_661 VDD VDD VSS VSS gf180mcu_fd_sc_mcu7t5v0__fillcap_4
XFILLER_92_683 VDD VDD VSS VSS gf180mcu_fd_sc_mcu7t5v0__fillcap_8
XFILLER_64_363 VDD VDD VSS VSS gf180mcu_fd_sc_mcu7t5v0__fillcap_16
XTAP_TAPCELL_ROW_22_417 VDD VSS gf180mcu_fd_sc_mcu7t5v0__filltie
XFILLER_60_591 VDD VDD VSS VSS gf180mcu_fd_sc_mcu7t5v0__fillcap_4
XFILLER_20_499 VDD VDD VSS VSS gf180mcu_fd_sc_mcu7t5v0__fill_2
X_0969_ _0906_/I _0907_/I _0973_/A3 VDD VDD VSS VSS gf180mcu_fd_sc_mcu7t5v0__nor2_1
XTAP_TAPCELL_ROW_30_494 VDD VSS gf180mcu_fd_sc_mcu7t5v0__filltie
XPHY_EDGE_ROW_18_Left_117 VDD VSS gf180mcu_fd_sc_mcu7t5v0__endcap
XFILLER_59_102 VDD VDD VSS VSS gf180mcu_fd_sc_mcu7t5v0__fillcap_32
XFILLER_87_422 VDD VDD VSS VSS gf180mcu_fd_sc_mcu7t5v0__fillcap_8
XFILLER_87_488 VDD VDD VSS VSS gf180mcu_fd_sc_mcu7t5v0__fill_2
XFILLER_68_691 VDD VDD VSS VSS gf180mcu_fd_sc_mcu7t5v0__fill_2
XPHY_EDGE_ROW_27_Left_126 VDD VSS gf180mcu_fd_sc_mcu7t5v0__endcap
XFILLER_74_37 VDD VDD VSS VSS gf180mcu_fd_sc_mcu7t5v0__fillcap_32
XTAP_TAPCELL_ROW_38_572 VDD VSS gf180mcu_fd_sc_mcu7t5v0__filltie
XFILLER_82_160 VDD VDD VSS VSS gf180mcu_fd_sc_mcu7t5v0__fillcap_8
XFILLER_43_514 VDD VDD VSS VSS gf180mcu_fd_sc_mcu7t5v0__fill_1
XFILLER_15_227 VDD VDD VSS VSS gf180mcu_fd_sc_mcu7t5v0__fill_1
XFILLER_11_422 VDD VDD VSS VSS gf180mcu_fd_sc_mcu7t5v0__fillcap_16
XFILLER_23_282 VDD VDD VSS VSS gf180mcu_fd_sc_mcu7t5v0__fillcap_8
XFILLER_70_399 VDD VDD VSS VSS gf180mcu_fd_sc_mcu7t5v0__fill_2
Xwire302 wire302/I cfg_data_o[23] VDD VDD VSS VSS gf180mcu_fd_sc_mcu7t5v0__clkbuf_3
Xwire357 wire357/I cfg_tx_startaddr_o[6] VDD VDD VSS VSS gf180mcu_fd_sc_mcu7t5v0__clkbuf_3
XPHY_EDGE_ROW_36_Left_135 VDD VSS gf180mcu_fd_sc_mcu7t5v0__endcap
Xwire368 wire368/I cfg_tx_size_o[7] VDD VDD VSS VSS gf180mcu_fd_sc_mcu7t5v0__clkbuf_3
Xwire379 wire379/I cfg_tx_size_o[11] VDD VDD VSS VSS gf180mcu_fd_sc_mcu7t5v0__clkbuf_3
XFILLER_3_632 VDD VDD VSS VSS gf180mcu_fd_sc_mcu7t5v0__fillcap_32
XFILLER_78_488 VDD VDD VSS VSS gf180mcu_fd_sc_mcu7t5v0__fillcap_8
XFILLER_78_477 VDD VDD VSS VSS gf180mcu_fd_sc_mcu7t5v0__fill_2
XFILLER_19_500 VDD VDD VSS VSS gf180mcu_fd_sc_mcu7t5v0__fill_1
XPHY_EDGE_ROW_45_Left_144 VDD VSS gf180mcu_fd_sc_mcu7t5v0__endcap
XFILLER_93_436 VDD VDD VSS VSS gf180mcu_fd_sc_mcu7t5v0__fill_1
XFILLER_59_680 VDD VDD VSS VSS gf180mcu_fd_sc_mcu7t5v0__fillcap_8
XFILLER_74_661 VDD VDD VSS VSS gf180mcu_fd_sc_mcu7t5v0__fillcap_4
XFILLER_58_190 VDD VDD VSS VSS gf180mcu_fd_sc_mcu7t5v0__fill_2
XTAP_TAPCELL_ROW_64_818 VDD VSS gf180mcu_fd_sc_mcu7t5v0__filltie
XFILLER_74_683 VDD VDD VSS VSS gf180mcu_fd_sc_mcu7t5v0__fillcap_8
XFILLER_21_208 VDD VDD VSS VSS gf180mcu_fd_sc_mcu7t5v0__fill_2
X_1941_ _1941_/D _1948_/RN _1949_/CLK _1941_/Q VDD VDD VSS VSS gf180mcu_fd_sc_mcu7t5v0__dffrnq_1
XTAP_TAPCELL_ROW_72_895 VDD VSS gf180mcu_fd_sc_mcu7t5v0__filltie
XFILLER_42_580 VDD VDD VSS VSS gf180mcu_fd_sc_mcu7t5v0__fillcap_8
XFILLER_14_293 VDD VDD VSS VSS gf180mcu_fd_sc_mcu7t5v0__fillcap_16
X_1872_ _1872_/D _1895_/RN _2155_/CLK _1872_/Q VDD VDD VSS VSS gf180mcu_fd_sc_mcu7t5v0__dffrnq_1
XPHY_EDGE_ROW_54_Left_153 VDD VSS gf180mcu_fd_sc_mcu7t5v0__endcap
XFILLER_9_76 VDD VDD VSS VSS gf180mcu_fd_sc_mcu7t5v0__fill_2
XFILLER_50_2 VDD VDD VSS VSS gf180mcu_fd_sc_mcu7t5v0__fillcap_32
XFILLER_69_422 VDD VDD VSS VSS gf180mcu_fd_sc_mcu7t5v0__fillcap_32
X_1306_ _1881_/Q _1873_/Q _1865_/Q _1857_/Q _1306_/S0 _1306_/S1 _1306_/Z VDD VDD VSS
+ VSS gf180mcu_fd_sc_mcu7t5v0__mux4_1
XPHY_EDGE_ROW_63_Left_162 VDD VSS gf180mcu_fd_sc_mcu7t5v0__endcap
XFILLER_96_241 VDD VDD VSS VSS gf180mcu_fd_sc_mcu7t5v0__fillcap_4
X_1237_ _1247_/A1 _1237_/A2 _1236_/Z _2142_/D VDD VDD VSS VSS gf180mcu_fd_sc_mcu7t5v0__nor3_1
X_1168_ _2052_/Q _2160_/Q _1169_/A2 VDD VDD VSS VSS gf180mcu_fd_sc_mcu7t5v0__nand2_1
XFILLER_52_311 VDD VDD VSS VSS gf180mcu_fd_sc_mcu7t5v0__fillcap_4
X_1099_ _2093_/Q _2169_/Q _1101_/B1 VDD VDD VSS VSS gf180mcu_fd_sc_mcu7t5v0__nand2_1
XTAP_TAPCELL_ROW_35_542 VDD VSS gf180mcu_fd_sc_mcu7t5v0__filltie
XFILLER_52_366 VDD VDD VSS VSS gf180mcu_fd_sc_mcu7t5v0__fillcap_16
XPHY_EDGE_ROW_72_Left_171 VDD VSS gf180mcu_fd_sc_mcu7t5v0__endcap
XPHY_EDGE_ROW_81_Left_180 VDD VSS gf180mcu_fd_sc_mcu7t5v0__endcap
XTAP_TAPCELL_ROW_7_278 VDD VSS gf180mcu_fd_sc_mcu7t5v0__filltie
XFILLER_47_138 VDD VDD VSS VSS gf180mcu_fd_sc_mcu7t5v0__fill_2
XFILLER_90_406 VDD VDD VSS VSS gf180mcu_fd_sc_mcu7t5v0__fillcap_16
XFILLER_56_683 VDD VDD VSS VSS gf180mcu_fd_sc_mcu7t5v0__fillcap_8
XFILLER_56_661 VDD VDD VSS VSS gf180mcu_fd_sc_mcu7t5v0__fillcap_4
XFILLER_71_620 VDD VDD VSS VSS gf180mcu_fd_sc_mcu7t5v0__fillcap_8
XFILLER_71_664 VDD VDD VSS VSS gf180mcu_fd_sc_mcu7t5v0__fillcap_16
XFILLER_70_141 VDD VDD VSS VSS gf180mcu_fd_sc_mcu7t5v0__fillcap_8
XFILLER_70_174 VDD VDD VSS VSS gf180mcu_fd_sc_mcu7t5v0__fill_1
XFILLER_34_84 VDD VDD VSS VSS gf180mcu_fd_sc_mcu7t5v0__fillcap_16
XFILLER_7_212 VDD VDD VSS VSS gf180mcu_fd_sc_mcu7t5v0__fillcap_4
XFILLER_98_506 VDD VDD VSS VSS gf180mcu_fd_sc_mcu7t5v0__fillcap_4
XFILLER_78_263 VDD VDD VSS VSS gf180mcu_fd_sc_mcu7t5v0__fillcap_8
XFILLER_39_606 VDD VDD VSS VSS gf180mcu_fd_sc_mcu7t5v0__fill_2
X_2140_ _2140_/D _2160_/RN _2142_/CLK _2140_/Q VDD VDD VSS VSS gf180mcu_fd_sc_mcu7t5v0__dffrnq_1
XFILLER_78_285 VDD VDD VSS VSS gf180mcu_fd_sc_mcu7t5v0__fill_1
X_2071_ _2071_/D _2082_/RN _2129_/CLK _2071_/Q VDD VDD VSS VSS gf180mcu_fd_sc_mcu7t5v0__dffsnq_1
XTAP_TAPCELL_ROW_77_943 VDD VSS gf180mcu_fd_sc_mcu7t5v0__filltie
XFILLER_66_469 VDD VDD VSS VSS gf180mcu_fd_sc_mcu7t5v0__fill_2
XFILLER_66_447 VDD VDD VSS VSS gf180mcu_fd_sc_mcu7t5v0__fillcap_8
X_1022_ _2089_/Q _2134_/Q _1022_/Z VDD VDD VSS VSS gf180mcu_fd_sc_mcu7t5v0__xor2_1
XTAP_TAPCELL_ROW_49_678 VDD VSS gf180mcu_fd_sc_mcu7t5v0__filltie
XFILLER_53_108 VDD VDD VSS VSS gf180mcu_fd_sc_mcu7t5v0__fill_1
XFILLER_19_385 VDD VDD VSS VSS gf180mcu_fd_sc_mcu7t5v0__fillcap_4
XFILLER_34_311 VDD VDD VSS VSS gf180mcu_fd_sc_mcu7t5v0__fillcap_4
XFILLER_46_193 VDD VDD VSS VSS gf180mcu_fd_sc_mcu7t5v0__fillcap_4
XFILLER_22_506 VDD VDD VSS VSS gf180mcu_fd_sc_mcu7t5v0__fillcap_16
XTAP_TAPCELL_ROW_32_512 VDD VSS gf180mcu_fd_sc_mcu7t5v0__filltie
XFILLER_98_2 VDD VDD VSS VSS gf180mcu_fd_sc_mcu7t5v0__fillcap_32
X_1924_ _1924_/D _1927_/RN _1961_/CLK _1924_/Q VDD VDD VSS VSS gf180mcu_fd_sc_mcu7t5v0__dffrnq_1
Xclkbuf_5_8__f_periph_clk_i clkbuf_4_4_0_periph_clk_i/Z _2156_/CLK VDD VDD VSS VSS
+ gf180mcu_fd_sc_mcu7t5v0__clkbuf_16
XFILLER_30_594 VDD VDD VSS VSS gf180mcu_fd_sc_mcu7t5v0__fill_1
X_1855_ _1977_/Q _2102_/Q _1855_/S _2102_/D VDD VDD VSS VSS gf180mcu_fd_sc_mcu7t5v0__mux2_2
X_1786_ _2074_/Q _1810_/A2 _1793_/B VDD VDD VSS VSS gf180mcu_fd_sc_mcu7t5v0__nand2_1
Xmax_cap421 _1939_/Q _1472_/S VDD VDD VSS VSS gf180mcu_fd_sc_mcu7t5v0__buf_2
XFILLER_39_18 VDD VDD VSS VSS gf180mcu_fd_sc_mcu7t5v0__fillcap_8
XTAP_TAPCELL_ROW_4_248 VDD VSS gf180mcu_fd_sc_mcu7t5v0__filltie
XFILLER_29_138 VDD VDD VSS VSS gf180mcu_fd_sc_mcu7t5v0__fill_2
XFILLER_84_255 VDD VDD VSS VSS gf180mcu_fd_sc_mcu7t5v0__fillcap_4
XFILLER_65_480 VDD VDD VSS VSS gf180mcu_fd_sc_mcu7t5v0__fill_1
XFILLER_40_325 VDD VDD VSS VSS gf180mcu_fd_sc_mcu7t5v0__fill_1
XFILLER_0_410 VDD VDD VSS VSS gf180mcu_fd_sc_mcu7t5v0__fill_2
XFILLER_88_583 VDD VDD VSS VSS gf180mcu_fd_sc_mcu7t5v0__fillcap_8
XTAP_TAPCELL_ROW_74_913 VDD VSS gf180mcu_fd_sc_mcu7t5v0__filltie
XFILLER_16_333 VDD VDD VSS VSS gf180mcu_fd_sc_mcu7t5v0__fillcap_8
XTAP_TAPCELL_ROW_46_648 VDD VSS gf180mcu_fd_sc_mcu7t5v0__filltie
XFILLER_90_247 VDD VDD VSS VSS gf180mcu_fd_sc_mcu7t5v0__fillcap_32
XFILLER_45_72 VDD VDD VSS VSS gf180mcu_fd_sc_mcu7t5v0__fillcap_16
XFILLER_31_314 VDD VDD VSS VSS gf180mcu_fd_sc_mcu7t5v0__fill_1
XTAP_TAPCELL_ROW_82_990 VDD VSS gf180mcu_fd_sc_mcu7t5v0__filltie
XFILLER_71_472 VDD VDD VSS VSS gf180mcu_fd_sc_mcu7t5v0__fill_1
X_1640_ _2011_/Q input32/Z _1641_/S _2011_/D VDD VDD VSS VSS gf180mcu_fd_sc_mcu7t5v0__mux2_2
XTAP_TAPCELL_ROW_96_1127 VDD VSS gf180mcu_fd_sc_mcu7t5v0__filltie
XFILLER_6_22 VDD VDD VSS VSS gf180mcu_fd_sc_mcu7t5v0__fillcap_8
X_1571_ _1571_/I0 _1950_/Q _1571_/S _1950_/D VDD VDD VSS VSS gf180mcu_fd_sc_mcu7t5v0__mux2_2
XFILLER_3_270 VDD VDD VSS VSS gf180mcu_fd_sc_mcu7t5v0__fillcap_4
X_2123_ _2123_/D _2123_/RN clkload8/I _2123_/Q VDD VDD VSS VSS gf180mcu_fd_sc_mcu7t5v0__dffrnq_1
XFILLER_66_244 VDD VDD VSS VSS gf180mcu_fd_sc_mcu7t5v0__fill_1
XFILLER_39_447 VDD VDD VSS VSS gf180mcu_fd_sc_mcu7t5v0__fillcap_32
XTAP_TAPCELL_ROW_1_218 VDD VSS gf180mcu_fd_sc_mcu7t5v0__filltie
XFILLER_94_597 VDD VDD VSS VSS gf180mcu_fd_sc_mcu7t5v0__fillcap_64
X_2054_ _2054_/D _2081_/RN _2157_/CLK _2054_/Q VDD VDD VSS VSS gf180mcu_fd_sc_mcu7t5v0__dffrnq_1
XFILLER_81_236 VDD VDD VSS VSS gf180mcu_fd_sc_mcu7t5v0__fillcap_4
X_1005_ _1501_/A3 _1501_/A2 _1496_/A3 VDD VDD VSS VSS gf180mcu_fd_sc_mcu7t5v0__nand2_1
XFILLER_22_314 VDD VDD VSS VSS gf180mcu_fd_sc_mcu7t5v0__fill_1
XFILLER_22_325 VDD VDD VSS VSS gf180mcu_fd_sc_mcu7t5v0__fill_2
XFILLER_34_185 VDD VDD VSS VSS gf180mcu_fd_sc_mcu7t5v0__fill_2
XTAP_TAPCELL_ROW_17_372 VDD VSS gf180mcu_fd_sc_mcu7t5v0__filltie
XFILLER_50_623 VDD VDD VSS VSS gf180mcu_fd_sc_mcu7t5v0__fill_1
XFILLER_50_667 VDD VDD VSS VSS gf180mcu_fd_sc_mcu7t5v0__fill_1
X_1907_ _1907_/D _1923_/RN clkload5/I _1907_/Q VDD VDD VSS VSS gf180mcu_fd_sc_mcu7t5v0__dffrnq_1
X_1838_ _1960_/Q _2085_/Q _1849_/S _2085_/D VDD VDD VSS VSS gf180mcu_fd_sc_mcu7t5v0__mux2_2
X_1769_ _1769_/A1 _1769_/A2 _1769_/B _1769_/C _2071_/D VDD VDD VSS VSS gf180mcu_fd_sc_mcu7t5v0__oai211_1
Xhold521 _2178_/Q _2179_/D VDD VDD VSS VSS gf180mcu_fd_sc_mcu7t5v0__dlyc_1
XFILLER_57_277 VDD VDD VSS VSS gf180mcu_fd_sc_mcu7t5v0__fill_2
XFILLER_38_491 VDD VDD VSS VSS gf180mcu_fd_sc_mcu7t5v0__fillcap_8
XFILLER_26_653 VDD VDD VSS VSS gf180mcu_fd_sc_mcu7t5v0__fill_2
XFILLER_82_37 VDD VDD VSS VSS gf180mcu_fd_sc_mcu7t5v0__fillcap_64
XFILLER_25_185 VDD VDD VSS VSS gf180mcu_fd_sc_mcu7t5v0__fillcap_16
XTAP_TAPCELL_ROW_43_618 VDD VSS gf180mcu_fd_sc_mcu7t5v0__filltie
XFILLER_41_612 VDD VDD VSS VSS gf180mcu_fd_sc_mcu7t5v0__fill_1
XFILLER_80_280 VDD VDD VSS VSS gf180mcu_fd_sc_mcu7t5v0__fillcap_16
XFILLER_9_329 VDD VDD VSS VSS gf180mcu_fd_sc_mcu7t5v0__fillcap_4
XFILLER_40_177 VDD VDD VSS VSS gf180mcu_fd_sc_mcu7t5v0__fillcap_16
XFILLER_21_380 VDD VDD VSS VSS gf180mcu_fd_sc_mcu7t5v0__fillcap_4
XTAP_TAPCELL_ROW_51_695 VDD VSS gf180mcu_fd_sc_mcu7t5v0__filltie
XFILLER_5_579 VDD VDD VSS VSS gf180mcu_fd_sc_mcu7t5v0__fill_1
XTAP_TAPCELL_ROW_91_1079 VDD VSS gf180mcu_fd_sc_mcu7t5v0__filltie
XFILLER_76_520 VDD VDD VSS VSS gf180mcu_fd_sc_mcu7t5v0__fillcap_4
XFILLER_48_244 VDD VDD VSS VSS gf180mcu_fd_sc_mcu7t5v0__fill_1
XTAP_TAPCELL_ROW_59_773 VDD VSS gf180mcu_fd_sc_mcu7t5v0__filltie
XFILLER_76_597 VDD VDD VSS VSS gf180mcu_fd_sc_mcu7t5v0__fill_2
XFILLER_56_82 VDD VDD VSS VSS gf180mcu_fd_sc_mcu7t5v0__fillcap_16
XFILLER_31_122 VDD VDD VSS VSS gf180mcu_fd_sc_mcu7t5v0__fill_1
XFILLER_31_133 VDD VDD VSS VSS gf180mcu_fd_sc_mcu7t5v0__fillcap_4
XFILLER_32_667 VDD VDD VSS VSS gf180mcu_fd_sc_mcu7t5v0__fill_2
XTAP_TAPCELL_ROW_14_342 VDD VSS gf180mcu_fd_sc_mcu7t5v0__filltie
XFILLER_8_384 VDD VDD VSS VSS gf180mcu_fd_sc_mcu7t5v0__fill_1
X_1623_ _1995_/Q input33/Z _1631_/S _1995_/D VDD VDD VSS VSS gf180mcu_fd_sc_mcu7t5v0__mux2_2
Xudma_uart_top_491 data_rx_o[15] VDD VDD VSS VSS gf180mcu_fd_sc_mcu7t5v0__tiel
Xudma_uart_top_480 cfg_tx_datasize_o[0] VDD VDD VSS VSS gf180mcu_fd_sc_mcu7t5v0__tiel
X_1554_ _1555_/A1 _1553_/B _1554_/Z VDD VDD VSS VSS gf180mcu_fd_sc_mcu7t5v0__and2_1
X_1485_ _1497_/A1 _1517_/A2 _1485_/B _1906_/D VDD VDD VSS VSS gf180mcu_fd_sc_mcu7t5v0__oai21_1
XFILLER_86_317 VDD VDD VSS VSS gf180mcu_fd_sc_mcu7t5v0__fillcap_8
.ends
